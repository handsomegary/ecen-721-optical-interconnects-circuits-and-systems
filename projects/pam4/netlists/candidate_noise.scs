simulator lang=spectre
include "__pdk_root__/models/spectre/pdk_toplevel.scs" section=tt
simulatorOptions options temp=25 tnom=25 reltol=1e-4 vabstol=1u iabstol=1p
// Schematic models with gate/contact/coupling parasitics enabled.
XVs (X_vdd 0) vsource dc=0.9
XVcm (X_cm 0) vsource dc=0.7
XVb (X_vb 0) vsource dc=0.58
XR1p (X_vdd X_c_p) resistor r=50
XM1p0 (X_c_p X_ip X_s1_p 0) nmos_lvt l=30n w=3u multi=1 nf=1 sd=100n ad=2.25e-13 as=2.25e-13 pd=6.15u ps=6.15u nrd=0.096480 nrs=0.096480 sa=75.0n sb=75.0n sa1=75.0n sa2=75.0n sa3=75.0n sa4=75.0n sb1=75.0n sb2=75.0n sb3=75.0n spa=100n spa1=100n spa2=100n spa3=100n sap=91.9776n sapb=114.444n spba=115.715n spba1=117.043n dfm_flag=0 _ccoflag=1 _rcoflag=1 _rgflag=1 spmt=1.11111e+15 spomt=0 spomt1=1.11111e+60 spmb=1.11111e+15 spomb=0 spomb1=1.11111e+60
XT1p0 (X_s1_p X_vb 0 0) nmos_lvt l=60n w=3u multi=1 nf=1 sd=100n ad=2.25e-13 as=2.25e-13 pd=6.15u ps=6.15u nrd=0.096480 nrs=0.096480 sa=75.0n sb=75.0n sa1=75.0n sa2=75.0n sa3=75.0n sa4=75.0n sb1=75.0n sb2=75.0n sb3=75.0n spa=100n spa1=100n spa2=100n spa3=100n sap=91.9776n sapb=120.93n spba=121.82n spba1=124.403n dfm_flag=0 _ccoflag=1 _rcoflag=1 _rgflag=1 spmt=1.11111e+15 spomt=0 spomt1=1.11111e+60 spmb=1.11111e+15 spomb=0 spomb1=1.11111e+60
XM1p1 (X_c_p X_ip X_s1_p 0) nmos_lvt l=30n w=3u multi=1 nf=1 sd=100n ad=2.25e-13 as=2.25e-13 pd=6.15u ps=6.15u nrd=0.096480 nrs=0.096480 sa=75.0n sb=75.0n sa1=75.0n sa2=75.0n sa3=75.0n sa4=75.0n sb1=75.0n sb2=75.0n sb3=75.0n spa=100n spa1=100n spa2=100n spa3=100n sap=91.9776n sapb=114.444n spba=115.715n spba1=117.043n dfm_flag=0 _ccoflag=1 _rcoflag=1 _rgflag=1 spmt=1.11111e+15 spomt=0 spomt1=1.11111e+60 spmb=1.11111e+15 spomb=0 spomb1=1.11111e+60
XT1p1 (X_s1_p X_vb 0 0) nmos_lvt l=60n w=3u multi=1 nf=1 sd=100n ad=2.25e-13 as=2.25e-13 pd=6.15u ps=6.15u nrd=0.096480 nrs=0.096480 sa=75.0n sb=75.0n sa1=75.0n sa2=75.0n sa3=75.0n sa4=75.0n sb1=75.0n sb2=75.0n sb3=75.0n spa=100n spa1=100n spa2=100n spa3=100n sap=91.9776n sapb=120.93n spba=121.82n spba1=124.403n dfm_flag=0 _ccoflag=1 _rcoflag=1 _rgflag=1 spmt=1.11111e+15 spomt=0 spomt1=1.11111e+60 spmb=1.11111e+15 spomb=0 spomb1=1.11111e+60
XM1p2 (X_c_p X_ip X_s1_p 0) nmos_lvt l=30n w=3u multi=1 nf=1 sd=100n ad=2.25e-13 as=2.25e-13 pd=6.15u ps=6.15u nrd=0.096480 nrs=0.096480 sa=75.0n sb=75.0n sa1=75.0n sa2=75.0n sa3=75.0n sa4=75.0n sb1=75.0n sb2=75.0n sb3=75.0n spa=100n spa1=100n spa2=100n spa3=100n sap=91.9776n sapb=114.444n spba=115.715n spba1=117.043n dfm_flag=0 _ccoflag=1 _rcoflag=1 _rgflag=1 spmt=1.11111e+15 spomt=0 spomt1=1.11111e+60 spmb=1.11111e+15 spomb=0 spomb1=1.11111e+60
XT1p2 (X_s1_p X_vb 0 0) nmos_lvt l=60n w=3u multi=1 nf=1 sd=100n ad=2.25e-13 as=2.25e-13 pd=6.15u ps=6.15u nrd=0.096480 nrs=0.096480 sa=75.0n sb=75.0n sa1=75.0n sa2=75.0n sa3=75.0n sa4=75.0n sb1=75.0n sb2=75.0n sb3=75.0n spa=100n spa1=100n spa2=100n spa3=100n sap=91.9776n sapb=120.93n spba=121.82n spba1=124.403n dfm_flag=0 _ccoflag=1 _rcoflag=1 _rgflag=1 spmt=1.11111e+15 spomt=0 spomt1=1.11111e+60 spmb=1.11111e+15 spomb=0 spomb1=1.11111e+60
XM1p3 (X_c_p X_ip X_s1_p 0) nmos_lvt l=30n w=3u multi=1 nf=1 sd=100n ad=2.25e-13 as=2.25e-13 pd=6.15u ps=6.15u nrd=0.096480 nrs=0.096480 sa=75.0n sb=75.0n sa1=75.0n sa2=75.0n sa3=75.0n sa4=75.0n sb1=75.0n sb2=75.0n sb3=75.0n spa=100n spa1=100n spa2=100n spa3=100n sap=91.9776n sapb=114.444n spba=115.715n spba1=117.043n dfm_flag=0 _ccoflag=1 _rcoflag=1 _rgflag=1 spmt=1.11111e+15 spomt=0 spomt1=1.11111e+60 spmb=1.11111e+15 spomb=0 spomb1=1.11111e+60
XT1p3 (X_s1_p X_vb 0 0) nmos_lvt l=60n w=3u multi=1 nf=1 sd=100n ad=2.25e-13 as=2.25e-13 pd=6.15u ps=6.15u nrd=0.096480 nrs=0.096480 sa=75.0n sb=75.0n sa1=75.0n sa2=75.0n sa3=75.0n sa4=75.0n sb1=75.0n sb2=75.0n sb3=75.0n spa=100n spa1=100n spa2=100n spa3=100n sap=91.9776n sapb=120.93n spba=121.82n spba1=124.403n dfm_flag=0 _ccoflag=1 _rcoflag=1 _rgflag=1 spmt=1.11111e+15 spomt=0 spomt1=1.11111e+60 spmb=1.11111e+15 spomb=0 spomb1=1.11111e+60
XM1p4 (X_c_p X_ip X_s1_p 0) nmos_lvt l=30n w=3u multi=1 nf=1 sd=100n ad=2.25e-13 as=2.25e-13 pd=6.15u ps=6.15u nrd=0.096480 nrs=0.096480 sa=75.0n sb=75.0n sa1=75.0n sa2=75.0n sa3=75.0n sa4=75.0n sb1=75.0n sb2=75.0n sb3=75.0n spa=100n spa1=100n spa2=100n spa3=100n sap=91.9776n sapb=114.444n spba=115.715n spba1=117.043n dfm_flag=0 _ccoflag=1 _rcoflag=1 _rgflag=1 spmt=1.11111e+15 spomt=0 spomt1=1.11111e+60 spmb=1.11111e+15 spomb=0 spomb1=1.11111e+60
XT1p4 (X_s1_p X_vb 0 0) nmos_lvt l=60n w=3u multi=1 nf=1 sd=100n ad=2.25e-13 as=2.25e-13 pd=6.15u ps=6.15u nrd=0.096480 nrs=0.096480 sa=75.0n sb=75.0n sa1=75.0n sa2=75.0n sa3=75.0n sa4=75.0n sb1=75.0n sb2=75.0n sb3=75.0n spa=100n spa1=100n spa2=100n spa3=100n sap=91.9776n sapb=120.93n spba=121.82n spba1=124.403n dfm_flag=0 _ccoflag=1 _rcoflag=1 _rgflag=1 spmt=1.11111e+15 spomt=0 spomt1=1.11111e+60 spmb=1.11111e+15 spomb=0 spomb1=1.11111e+60
XM1p5 (X_c_p X_ip X_s1_p 0) nmos_lvt l=30n w=3u multi=1 nf=1 sd=100n ad=2.25e-13 as=2.25e-13 pd=6.15u ps=6.15u nrd=0.096480 nrs=0.096480 sa=75.0n sb=75.0n sa1=75.0n sa2=75.0n sa3=75.0n sa4=75.0n sb1=75.0n sb2=75.0n sb3=75.0n spa=100n spa1=100n spa2=100n spa3=100n sap=91.9776n sapb=114.444n spba=115.715n spba1=117.043n dfm_flag=0 _ccoflag=1 _rcoflag=1 _rgflag=1 spmt=1.11111e+15 spomt=0 spomt1=1.11111e+60 spmb=1.11111e+15 spomb=0 spomb1=1.11111e+60
XT1p5 (X_s1_p X_vb 0 0) nmos_lvt l=60n w=3u multi=1 nf=1 sd=100n ad=2.25e-13 as=2.25e-13 pd=6.15u ps=6.15u nrd=0.096480 nrs=0.096480 sa=75.0n sb=75.0n sa1=75.0n sa2=75.0n sa3=75.0n sa4=75.0n sb1=75.0n sb2=75.0n sb3=75.0n spa=100n spa1=100n spa2=100n spa3=100n sap=91.9776n sapb=120.93n spba=121.82n spba1=124.403n dfm_flag=0 _ccoflag=1 _rcoflag=1 _rgflag=1 spmt=1.11111e+15 spomt=0 spomt1=1.11111e+60 spmb=1.11111e+15 spomb=0 spomb1=1.11111e+60
XM1p6 (X_c_p X_ip X_s1_p 0) nmos_lvt l=30n w=3u multi=1 nf=1 sd=100n ad=2.25e-13 as=2.25e-13 pd=6.15u ps=6.15u nrd=0.096480 nrs=0.096480 sa=75.0n sb=75.0n sa1=75.0n sa2=75.0n sa3=75.0n sa4=75.0n sb1=75.0n sb2=75.0n sb3=75.0n spa=100n spa1=100n spa2=100n spa3=100n sap=91.9776n sapb=114.444n spba=115.715n spba1=117.043n dfm_flag=0 _ccoflag=1 _rcoflag=1 _rgflag=1 spmt=1.11111e+15 spomt=0 spomt1=1.11111e+60 spmb=1.11111e+15 spomb=0 spomb1=1.11111e+60
XT1p6 (X_s1_p X_vb 0 0) nmos_lvt l=60n w=3u multi=1 nf=1 sd=100n ad=2.25e-13 as=2.25e-13 pd=6.15u ps=6.15u nrd=0.096480 nrs=0.096480 sa=75.0n sb=75.0n sa1=75.0n sa2=75.0n sa3=75.0n sa4=75.0n sb1=75.0n sb2=75.0n sb3=75.0n spa=100n spa1=100n spa2=100n spa3=100n sap=91.9776n sapb=120.93n spba=121.82n spba1=124.403n dfm_flag=0 _ccoflag=1 _rcoflag=1 _rgflag=1 spmt=1.11111e+15 spomt=0 spomt1=1.11111e+60 spmb=1.11111e+15 spomb=0 spomb1=1.11111e+60
XM1p7 (X_c_p X_ip X_s1_p 0) nmos_lvt l=30n w=3u multi=1 nf=1 sd=100n ad=2.25e-13 as=2.25e-13 pd=6.15u ps=6.15u nrd=0.096480 nrs=0.096480 sa=75.0n sb=75.0n sa1=75.0n sa2=75.0n sa3=75.0n sa4=75.0n sb1=75.0n sb2=75.0n sb3=75.0n spa=100n spa1=100n spa2=100n spa3=100n sap=91.9776n sapb=114.444n spba=115.715n spba1=117.043n dfm_flag=0 _ccoflag=1 _rcoflag=1 _rgflag=1 spmt=1.11111e+15 spomt=0 spomt1=1.11111e+60 spmb=1.11111e+15 spomb=0 spomb1=1.11111e+60
XT1p7 (X_s1_p X_vb 0 0) nmos_lvt l=60n w=3u multi=1 nf=1 sd=100n ad=2.25e-13 as=2.25e-13 pd=6.15u ps=6.15u nrd=0.096480 nrs=0.096480 sa=75.0n sb=75.0n sa1=75.0n sa2=75.0n sa3=75.0n sa4=75.0n sb1=75.0n sb2=75.0n sb3=75.0n spa=100n spa1=100n spa2=100n spa3=100n sap=91.9776n sapb=120.93n spba=121.82n spba1=124.403n dfm_flag=0 _ccoflag=1 _rcoflag=1 _rgflag=1 spmt=1.11111e+15 spomt=0 spomt1=1.11111e+60 spmb=1.11111e+15 spomb=0 spomb1=1.11111e+60
XR1m (X_vdd X_c_m) resistor r=50
XM1m0 (X_c_m X_im X_s1_m 0) nmos_lvt l=30n w=3u multi=1 nf=1 sd=100n ad=2.25e-13 as=2.25e-13 pd=6.15u ps=6.15u nrd=0.096480 nrs=0.096480 sa=75.0n sb=75.0n sa1=75.0n sa2=75.0n sa3=75.0n sa4=75.0n sb1=75.0n sb2=75.0n sb3=75.0n spa=100n spa1=100n spa2=100n spa3=100n sap=91.9776n sapb=114.444n spba=115.715n spba1=117.043n dfm_flag=0 _ccoflag=1 _rcoflag=1 _rgflag=1 spmt=1.11111e+15 spomt=0 spomt1=1.11111e+60 spmb=1.11111e+15 spomb=0 spomb1=1.11111e+60
XT1m0 (X_s1_m X_vb 0 0) nmos_lvt l=60n w=3u multi=1 nf=1 sd=100n ad=2.25e-13 as=2.25e-13 pd=6.15u ps=6.15u nrd=0.096480 nrs=0.096480 sa=75.0n sb=75.0n sa1=75.0n sa2=75.0n sa3=75.0n sa4=75.0n sb1=75.0n sb2=75.0n sb3=75.0n spa=100n spa1=100n spa2=100n spa3=100n sap=91.9776n sapb=120.93n spba=121.82n spba1=124.403n dfm_flag=0 _ccoflag=1 _rcoflag=1 _rgflag=1 spmt=1.11111e+15 spomt=0 spomt1=1.11111e+60 spmb=1.11111e+15 spomb=0 spomb1=1.11111e+60
XM1m1 (X_c_m X_im X_s1_m 0) nmos_lvt l=30n w=3u multi=1 nf=1 sd=100n ad=2.25e-13 as=2.25e-13 pd=6.15u ps=6.15u nrd=0.096480 nrs=0.096480 sa=75.0n sb=75.0n sa1=75.0n sa2=75.0n sa3=75.0n sa4=75.0n sb1=75.0n sb2=75.0n sb3=75.0n spa=100n spa1=100n spa2=100n spa3=100n sap=91.9776n sapb=114.444n spba=115.715n spba1=117.043n dfm_flag=0 _ccoflag=1 _rcoflag=1 _rgflag=1 spmt=1.11111e+15 spomt=0 spomt1=1.11111e+60 spmb=1.11111e+15 spomb=0 spomb1=1.11111e+60
XT1m1 (X_s1_m X_vb 0 0) nmos_lvt l=60n w=3u multi=1 nf=1 sd=100n ad=2.25e-13 as=2.25e-13 pd=6.15u ps=6.15u nrd=0.096480 nrs=0.096480 sa=75.0n sb=75.0n sa1=75.0n sa2=75.0n sa3=75.0n sa4=75.0n sb1=75.0n sb2=75.0n sb3=75.0n spa=100n spa1=100n spa2=100n spa3=100n sap=91.9776n sapb=120.93n spba=121.82n spba1=124.403n dfm_flag=0 _ccoflag=1 _rcoflag=1 _rgflag=1 spmt=1.11111e+15 spomt=0 spomt1=1.11111e+60 spmb=1.11111e+15 spomb=0 spomb1=1.11111e+60
XM1m2 (X_c_m X_im X_s1_m 0) nmos_lvt l=30n w=3u multi=1 nf=1 sd=100n ad=2.25e-13 as=2.25e-13 pd=6.15u ps=6.15u nrd=0.096480 nrs=0.096480 sa=75.0n sb=75.0n sa1=75.0n sa2=75.0n sa3=75.0n sa4=75.0n sb1=75.0n sb2=75.0n sb3=75.0n spa=100n spa1=100n spa2=100n spa3=100n sap=91.9776n sapb=114.444n spba=115.715n spba1=117.043n dfm_flag=0 _ccoflag=1 _rcoflag=1 _rgflag=1 spmt=1.11111e+15 spomt=0 spomt1=1.11111e+60 spmb=1.11111e+15 spomb=0 spomb1=1.11111e+60
XT1m2 (X_s1_m X_vb 0 0) nmos_lvt l=60n w=3u multi=1 nf=1 sd=100n ad=2.25e-13 as=2.25e-13 pd=6.15u ps=6.15u nrd=0.096480 nrs=0.096480 sa=75.0n sb=75.0n sa1=75.0n sa2=75.0n sa3=75.0n sa4=75.0n sb1=75.0n sb2=75.0n sb3=75.0n spa=100n spa1=100n spa2=100n spa3=100n sap=91.9776n sapb=120.93n spba=121.82n spba1=124.403n dfm_flag=0 _ccoflag=1 _rcoflag=1 _rgflag=1 spmt=1.11111e+15 spomt=0 spomt1=1.11111e+60 spmb=1.11111e+15 spomb=0 spomb1=1.11111e+60
XM1m3 (X_c_m X_im X_s1_m 0) nmos_lvt l=30n w=3u multi=1 nf=1 sd=100n ad=2.25e-13 as=2.25e-13 pd=6.15u ps=6.15u nrd=0.096480 nrs=0.096480 sa=75.0n sb=75.0n sa1=75.0n sa2=75.0n sa3=75.0n sa4=75.0n sb1=75.0n sb2=75.0n sb3=75.0n spa=100n spa1=100n spa2=100n spa3=100n sap=91.9776n sapb=114.444n spba=115.715n spba1=117.043n dfm_flag=0 _ccoflag=1 _rcoflag=1 _rgflag=1 spmt=1.11111e+15 spomt=0 spomt1=1.11111e+60 spmb=1.11111e+15 spomb=0 spomb1=1.11111e+60
XT1m3 (X_s1_m X_vb 0 0) nmos_lvt l=60n w=3u multi=1 nf=1 sd=100n ad=2.25e-13 as=2.25e-13 pd=6.15u ps=6.15u nrd=0.096480 nrs=0.096480 sa=75.0n sb=75.0n sa1=75.0n sa2=75.0n sa3=75.0n sa4=75.0n sb1=75.0n sb2=75.0n sb3=75.0n spa=100n spa1=100n spa2=100n spa3=100n sap=91.9776n sapb=120.93n spba=121.82n spba1=124.403n dfm_flag=0 _ccoflag=1 _rcoflag=1 _rgflag=1 spmt=1.11111e+15 spomt=0 spomt1=1.11111e+60 spmb=1.11111e+15 spomb=0 spomb1=1.11111e+60
XM1m4 (X_c_m X_im X_s1_m 0) nmos_lvt l=30n w=3u multi=1 nf=1 sd=100n ad=2.25e-13 as=2.25e-13 pd=6.15u ps=6.15u nrd=0.096480 nrs=0.096480 sa=75.0n sb=75.0n sa1=75.0n sa2=75.0n sa3=75.0n sa4=75.0n sb1=75.0n sb2=75.0n sb3=75.0n spa=100n spa1=100n spa2=100n spa3=100n sap=91.9776n sapb=114.444n spba=115.715n spba1=117.043n dfm_flag=0 _ccoflag=1 _rcoflag=1 _rgflag=1 spmt=1.11111e+15 spomt=0 spomt1=1.11111e+60 spmb=1.11111e+15 spomb=0 spomb1=1.11111e+60
XT1m4 (X_s1_m X_vb 0 0) nmos_lvt l=60n w=3u multi=1 nf=1 sd=100n ad=2.25e-13 as=2.25e-13 pd=6.15u ps=6.15u nrd=0.096480 nrs=0.096480 sa=75.0n sb=75.0n sa1=75.0n sa2=75.0n sa3=75.0n sa4=75.0n sb1=75.0n sb2=75.0n sb3=75.0n spa=100n spa1=100n spa2=100n spa3=100n sap=91.9776n sapb=120.93n spba=121.82n spba1=124.403n dfm_flag=0 _ccoflag=1 _rcoflag=1 _rgflag=1 spmt=1.11111e+15 spomt=0 spomt1=1.11111e+60 spmb=1.11111e+15 spomb=0 spomb1=1.11111e+60
XM1m5 (X_c_m X_im X_s1_m 0) nmos_lvt l=30n w=3u multi=1 nf=1 sd=100n ad=2.25e-13 as=2.25e-13 pd=6.15u ps=6.15u nrd=0.096480 nrs=0.096480 sa=75.0n sb=75.0n sa1=75.0n sa2=75.0n sa3=75.0n sa4=75.0n sb1=75.0n sb2=75.0n sb3=75.0n spa=100n spa1=100n spa2=100n spa3=100n sap=91.9776n sapb=114.444n spba=115.715n spba1=117.043n dfm_flag=0 _ccoflag=1 _rcoflag=1 _rgflag=1 spmt=1.11111e+15 spomt=0 spomt1=1.11111e+60 spmb=1.11111e+15 spomb=0 spomb1=1.11111e+60
XT1m5 (X_s1_m X_vb 0 0) nmos_lvt l=60n w=3u multi=1 nf=1 sd=100n ad=2.25e-13 as=2.25e-13 pd=6.15u ps=6.15u nrd=0.096480 nrs=0.096480 sa=75.0n sb=75.0n sa1=75.0n sa2=75.0n sa3=75.0n sa4=75.0n sb1=75.0n sb2=75.0n sb3=75.0n spa=100n spa1=100n spa2=100n spa3=100n sap=91.9776n sapb=120.93n spba=121.82n spba1=124.403n dfm_flag=0 _ccoflag=1 _rcoflag=1 _rgflag=1 spmt=1.11111e+15 spomt=0 spomt1=1.11111e+60 spmb=1.11111e+15 spomb=0 spomb1=1.11111e+60
XM1m6 (X_c_m X_im X_s1_m 0) nmos_lvt l=30n w=3u multi=1 nf=1 sd=100n ad=2.25e-13 as=2.25e-13 pd=6.15u ps=6.15u nrd=0.096480 nrs=0.096480 sa=75.0n sb=75.0n sa1=75.0n sa2=75.0n sa3=75.0n sa4=75.0n sb1=75.0n sb2=75.0n sb3=75.0n spa=100n spa1=100n spa2=100n spa3=100n sap=91.9776n sapb=114.444n spba=115.715n spba1=117.043n dfm_flag=0 _ccoflag=1 _rcoflag=1 _rgflag=1 spmt=1.11111e+15 spomt=0 spomt1=1.11111e+60 spmb=1.11111e+15 spomb=0 spomb1=1.11111e+60
XT1m6 (X_s1_m X_vb 0 0) nmos_lvt l=60n w=3u multi=1 nf=1 sd=100n ad=2.25e-13 as=2.25e-13 pd=6.15u ps=6.15u nrd=0.096480 nrs=0.096480 sa=75.0n sb=75.0n sa1=75.0n sa2=75.0n sa3=75.0n sa4=75.0n sb1=75.0n sb2=75.0n sb3=75.0n spa=100n spa1=100n spa2=100n spa3=100n sap=91.9776n sapb=120.93n spba=121.82n spba1=124.403n dfm_flag=0 _ccoflag=1 _rcoflag=1 _rgflag=1 spmt=1.11111e+15 spomt=0 spomt1=1.11111e+60 spmb=1.11111e+15 spomb=0 spomb1=1.11111e+60
XM1m7 (X_c_m X_im X_s1_m 0) nmos_lvt l=30n w=3u multi=1 nf=1 sd=100n ad=2.25e-13 as=2.25e-13 pd=6.15u ps=6.15u nrd=0.096480 nrs=0.096480 sa=75.0n sb=75.0n sa1=75.0n sa2=75.0n sa3=75.0n sa4=75.0n sb1=75.0n sb2=75.0n sb3=75.0n spa=100n spa1=100n spa2=100n spa3=100n sap=91.9776n sapb=114.444n spba=115.715n spba1=117.043n dfm_flag=0 _ccoflag=1 _rcoflag=1 _rgflag=1 spmt=1.11111e+15 spomt=0 spomt1=1.11111e+60 spmb=1.11111e+15 spomb=0 spomb1=1.11111e+60
XT1m7 (X_s1_m X_vb 0 0) nmos_lvt l=60n w=3u multi=1 nf=1 sd=100n ad=2.25e-13 as=2.25e-13 pd=6.15u ps=6.15u nrd=0.096480 nrs=0.096480 sa=75.0n sb=75.0n sa1=75.0n sa2=75.0n sa3=75.0n sa4=75.0n sb1=75.0n sb2=75.0n sb3=75.0n spa=100n spa1=100n spa2=100n spa3=100n sap=91.9776n sapb=120.93n spba=121.82n spba1=124.403n dfm_flag=0 _ccoflag=1 _rcoflag=1 _rgflag=1 spmt=1.11111e+15 spomt=0 spomt1=1.11111e+60 spmb=1.11111e+15 spomb=0 spomb1=1.11111e+60
XRdeg1 (X_s1_p X_s1_m) resistor r=250
XCdeg1 (X_s1_p X_s1_m) capacitor c=1e-13
XR2p (X_vdd X_o_p) resistor r=50
XM2p0 (X_o_p X_c_p X_s2_p 0) nmos_lvt l=30n w=3u multi=1 nf=1 sd=100n ad=2.25e-13 as=2.25e-13 pd=6.15u ps=6.15u nrd=0.096480 nrs=0.096480 sa=75.0n sb=75.0n sa1=75.0n sa2=75.0n sa3=75.0n sa4=75.0n sb1=75.0n sb2=75.0n sb3=75.0n spa=100n spa1=100n spa2=100n spa3=100n sap=91.9776n sapb=114.444n spba=115.715n spba1=117.043n dfm_flag=0 _ccoflag=1 _rcoflag=1 _rgflag=1 spmt=1.11111e+15 spomt=0 spomt1=1.11111e+60 spmb=1.11111e+15 spomb=0 spomb1=1.11111e+60
XT2p0 (X_s2_p X_vb 0 0) nmos_lvt l=60n w=3u multi=1 nf=1 sd=100n ad=2.25e-13 as=2.25e-13 pd=6.15u ps=6.15u nrd=0.096480 nrs=0.096480 sa=75.0n sb=75.0n sa1=75.0n sa2=75.0n sa3=75.0n sa4=75.0n sb1=75.0n sb2=75.0n sb3=75.0n spa=100n spa1=100n spa2=100n spa3=100n sap=91.9776n sapb=120.93n spba=121.82n spba1=124.403n dfm_flag=0 _ccoflag=1 _rcoflag=1 _rgflag=1 spmt=1.11111e+15 spomt=0 spomt1=1.11111e+60 spmb=1.11111e+15 spomb=0 spomb1=1.11111e+60
XM2p1 (X_o_p X_c_p X_s2_p 0) nmos_lvt l=30n w=3u multi=1 nf=1 sd=100n ad=2.25e-13 as=2.25e-13 pd=6.15u ps=6.15u nrd=0.096480 nrs=0.096480 sa=75.0n sb=75.0n sa1=75.0n sa2=75.0n sa3=75.0n sa4=75.0n sb1=75.0n sb2=75.0n sb3=75.0n spa=100n spa1=100n spa2=100n spa3=100n sap=91.9776n sapb=114.444n spba=115.715n spba1=117.043n dfm_flag=0 _ccoflag=1 _rcoflag=1 _rgflag=1 spmt=1.11111e+15 spomt=0 spomt1=1.11111e+60 spmb=1.11111e+15 spomb=0 spomb1=1.11111e+60
XT2p1 (X_s2_p X_vb 0 0) nmos_lvt l=60n w=3u multi=1 nf=1 sd=100n ad=2.25e-13 as=2.25e-13 pd=6.15u ps=6.15u nrd=0.096480 nrs=0.096480 sa=75.0n sb=75.0n sa1=75.0n sa2=75.0n sa3=75.0n sa4=75.0n sb1=75.0n sb2=75.0n sb3=75.0n spa=100n spa1=100n spa2=100n spa3=100n sap=91.9776n sapb=120.93n spba=121.82n spba1=124.403n dfm_flag=0 _ccoflag=1 _rcoflag=1 _rgflag=1 spmt=1.11111e+15 spomt=0 spomt1=1.11111e+60 spmb=1.11111e+15 spomb=0 spomb1=1.11111e+60
XM2p2 (X_o_p X_c_p X_s2_p 0) nmos_lvt l=30n w=3u multi=1 nf=1 sd=100n ad=2.25e-13 as=2.25e-13 pd=6.15u ps=6.15u nrd=0.096480 nrs=0.096480 sa=75.0n sb=75.0n sa1=75.0n sa2=75.0n sa3=75.0n sa4=75.0n sb1=75.0n sb2=75.0n sb3=75.0n spa=100n spa1=100n spa2=100n spa3=100n sap=91.9776n sapb=114.444n spba=115.715n spba1=117.043n dfm_flag=0 _ccoflag=1 _rcoflag=1 _rgflag=1 spmt=1.11111e+15 spomt=0 spomt1=1.11111e+60 spmb=1.11111e+15 spomb=0 spomb1=1.11111e+60
XT2p2 (X_s2_p X_vb 0 0) nmos_lvt l=60n w=3u multi=1 nf=1 sd=100n ad=2.25e-13 as=2.25e-13 pd=6.15u ps=6.15u nrd=0.096480 nrs=0.096480 sa=75.0n sb=75.0n sa1=75.0n sa2=75.0n sa3=75.0n sa4=75.0n sb1=75.0n sb2=75.0n sb3=75.0n spa=100n spa1=100n spa2=100n spa3=100n sap=91.9776n sapb=120.93n spba=121.82n spba1=124.403n dfm_flag=0 _ccoflag=1 _rcoflag=1 _rgflag=1 spmt=1.11111e+15 spomt=0 spomt1=1.11111e+60 spmb=1.11111e+15 spomb=0 spomb1=1.11111e+60
XM2p3 (X_o_p X_c_p X_s2_p 0) nmos_lvt l=30n w=3u multi=1 nf=1 sd=100n ad=2.25e-13 as=2.25e-13 pd=6.15u ps=6.15u nrd=0.096480 nrs=0.096480 sa=75.0n sb=75.0n sa1=75.0n sa2=75.0n sa3=75.0n sa4=75.0n sb1=75.0n sb2=75.0n sb3=75.0n spa=100n spa1=100n spa2=100n spa3=100n sap=91.9776n sapb=114.444n spba=115.715n spba1=117.043n dfm_flag=0 _ccoflag=1 _rcoflag=1 _rgflag=1 spmt=1.11111e+15 spomt=0 spomt1=1.11111e+60 spmb=1.11111e+15 spomb=0 spomb1=1.11111e+60
XT2p3 (X_s2_p X_vb 0 0) nmos_lvt l=60n w=3u multi=1 nf=1 sd=100n ad=2.25e-13 as=2.25e-13 pd=6.15u ps=6.15u nrd=0.096480 nrs=0.096480 sa=75.0n sb=75.0n sa1=75.0n sa2=75.0n sa3=75.0n sa4=75.0n sb1=75.0n sb2=75.0n sb3=75.0n spa=100n spa1=100n spa2=100n spa3=100n sap=91.9776n sapb=120.93n spba=121.82n spba1=124.403n dfm_flag=0 _ccoflag=1 _rcoflag=1 _rgflag=1 spmt=1.11111e+15 spomt=0 spomt1=1.11111e+60 spmb=1.11111e+15 spomb=0 spomb1=1.11111e+60
XM2p4 (X_o_p X_c_p X_s2_p 0) nmos_lvt l=30n w=3u multi=1 nf=1 sd=100n ad=2.25e-13 as=2.25e-13 pd=6.15u ps=6.15u nrd=0.096480 nrs=0.096480 sa=75.0n sb=75.0n sa1=75.0n sa2=75.0n sa3=75.0n sa4=75.0n sb1=75.0n sb2=75.0n sb3=75.0n spa=100n spa1=100n spa2=100n spa3=100n sap=91.9776n sapb=114.444n spba=115.715n spba1=117.043n dfm_flag=0 _ccoflag=1 _rcoflag=1 _rgflag=1 spmt=1.11111e+15 spomt=0 spomt1=1.11111e+60 spmb=1.11111e+15 spomb=0 spomb1=1.11111e+60
XT2p4 (X_s2_p X_vb 0 0) nmos_lvt l=60n w=3u multi=1 nf=1 sd=100n ad=2.25e-13 as=2.25e-13 pd=6.15u ps=6.15u nrd=0.096480 nrs=0.096480 sa=75.0n sb=75.0n sa1=75.0n sa2=75.0n sa3=75.0n sa4=75.0n sb1=75.0n sb2=75.0n sb3=75.0n spa=100n spa1=100n spa2=100n spa3=100n sap=91.9776n sapb=120.93n spba=121.82n spba1=124.403n dfm_flag=0 _ccoflag=1 _rcoflag=1 _rgflag=1 spmt=1.11111e+15 spomt=0 spomt1=1.11111e+60 spmb=1.11111e+15 spomb=0 spomb1=1.11111e+60
XM2p5 (X_o_p X_c_p X_s2_p 0) nmos_lvt l=30n w=3u multi=1 nf=1 sd=100n ad=2.25e-13 as=2.25e-13 pd=6.15u ps=6.15u nrd=0.096480 nrs=0.096480 sa=75.0n sb=75.0n sa1=75.0n sa2=75.0n sa3=75.0n sa4=75.0n sb1=75.0n sb2=75.0n sb3=75.0n spa=100n spa1=100n spa2=100n spa3=100n sap=91.9776n sapb=114.444n spba=115.715n spba1=117.043n dfm_flag=0 _ccoflag=1 _rcoflag=1 _rgflag=1 spmt=1.11111e+15 spomt=0 spomt1=1.11111e+60 spmb=1.11111e+15 spomb=0 spomb1=1.11111e+60
XT2p5 (X_s2_p X_vb 0 0) nmos_lvt l=60n w=3u multi=1 nf=1 sd=100n ad=2.25e-13 as=2.25e-13 pd=6.15u ps=6.15u nrd=0.096480 nrs=0.096480 sa=75.0n sb=75.0n sa1=75.0n sa2=75.0n sa3=75.0n sa4=75.0n sb1=75.0n sb2=75.0n sb3=75.0n spa=100n spa1=100n spa2=100n spa3=100n sap=91.9776n sapb=120.93n spba=121.82n spba1=124.403n dfm_flag=0 _ccoflag=1 _rcoflag=1 _rgflag=1 spmt=1.11111e+15 spomt=0 spomt1=1.11111e+60 spmb=1.11111e+15 spomb=0 spomb1=1.11111e+60
XM2p6 (X_o_p X_c_p X_s2_p 0) nmos_lvt l=30n w=3u multi=1 nf=1 sd=100n ad=2.25e-13 as=2.25e-13 pd=6.15u ps=6.15u nrd=0.096480 nrs=0.096480 sa=75.0n sb=75.0n sa1=75.0n sa2=75.0n sa3=75.0n sa4=75.0n sb1=75.0n sb2=75.0n sb3=75.0n spa=100n spa1=100n spa2=100n spa3=100n sap=91.9776n sapb=114.444n spba=115.715n spba1=117.043n dfm_flag=0 _ccoflag=1 _rcoflag=1 _rgflag=1 spmt=1.11111e+15 spomt=0 spomt1=1.11111e+60 spmb=1.11111e+15 spomb=0 spomb1=1.11111e+60
XT2p6 (X_s2_p X_vb 0 0) nmos_lvt l=60n w=3u multi=1 nf=1 sd=100n ad=2.25e-13 as=2.25e-13 pd=6.15u ps=6.15u nrd=0.096480 nrs=0.096480 sa=75.0n sb=75.0n sa1=75.0n sa2=75.0n sa3=75.0n sa4=75.0n sb1=75.0n sb2=75.0n sb3=75.0n spa=100n spa1=100n spa2=100n spa3=100n sap=91.9776n sapb=120.93n spba=121.82n spba1=124.403n dfm_flag=0 _ccoflag=1 _rcoflag=1 _rgflag=1 spmt=1.11111e+15 spomt=0 spomt1=1.11111e+60 spmb=1.11111e+15 spomb=0 spomb1=1.11111e+60
XM2p7 (X_o_p X_c_p X_s2_p 0) nmos_lvt l=30n w=3u multi=1 nf=1 sd=100n ad=2.25e-13 as=2.25e-13 pd=6.15u ps=6.15u nrd=0.096480 nrs=0.096480 sa=75.0n sb=75.0n sa1=75.0n sa2=75.0n sa3=75.0n sa4=75.0n sb1=75.0n sb2=75.0n sb3=75.0n spa=100n spa1=100n spa2=100n spa3=100n sap=91.9776n sapb=114.444n spba=115.715n spba1=117.043n dfm_flag=0 _ccoflag=1 _rcoflag=1 _rgflag=1 spmt=1.11111e+15 spomt=0 spomt1=1.11111e+60 spmb=1.11111e+15 spomb=0 spomb1=1.11111e+60
XT2p7 (X_s2_p X_vb 0 0) nmos_lvt l=60n w=3u multi=1 nf=1 sd=100n ad=2.25e-13 as=2.25e-13 pd=6.15u ps=6.15u nrd=0.096480 nrs=0.096480 sa=75.0n sb=75.0n sa1=75.0n sa2=75.0n sa3=75.0n sa4=75.0n sb1=75.0n sb2=75.0n sb3=75.0n spa=100n spa1=100n spa2=100n spa3=100n sap=91.9776n sapb=120.93n spba=121.82n spba1=124.403n dfm_flag=0 _ccoflag=1 _rcoflag=1 _rgflag=1 spmt=1.11111e+15 spomt=0 spomt1=1.11111e+60 spmb=1.11111e+15 spomb=0 spomb1=1.11111e+60
XR2m (X_vdd X_o_m) resistor r=50
XM2m0 (X_o_m X_c_m X_s2_m 0) nmos_lvt l=30n w=3u multi=1 nf=1 sd=100n ad=2.25e-13 as=2.25e-13 pd=6.15u ps=6.15u nrd=0.096480 nrs=0.096480 sa=75.0n sb=75.0n sa1=75.0n sa2=75.0n sa3=75.0n sa4=75.0n sb1=75.0n sb2=75.0n sb3=75.0n spa=100n spa1=100n spa2=100n spa3=100n sap=91.9776n sapb=114.444n spba=115.715n spba1=117.043n dfm_flag=0 _ccoflag=1 _rcoflag=1 _rgflag=1 spmt=1.11111e+15 spomt=0 spomt1=1.11111e+60 spmb=1.11111e+15 spomb=0 spomb1=1.11111e+60
XT2m0 (X_s2_m X_vb 0 0) nmos_lvt l=60n w=3u multi=1 nf=1 sd=100n ad=2.25e-13 as=2.25e-13 pd=6.15u ps=6.15u nrd=0.096480 nrs=0.096480 sa=75.0n sb=75.0n sa1=75.0n sa2=75.0n sa3=75.0n sa4=75.0n sb1=75.0n sb2=75.0n sb3=75.0n spa=100n spa1=100n spa2=100n spa3=100n sap=91.9776n sapb=120.93n spba=121.82n spba1=124.403n dfm_flag=0 _ccoflag=1 _rcoflag=1 _rgflag=1 spmt=1.11111e+15 spomt=0 spomt1=1.11111e+60 spmb=1.11111e+15 spomb=0 spomb1=1.11111e+60
XM2m1 (X_o_m X_c_m X_s2_m 0) nmos_lvt l=30n w=3u multi=1 nf=1 sd=100n ad=2.25e-13 as=2.25e-13 pd=6.15u ps=6.15u nrd=0.096480 nrs=0.096480 sa=75.0n sb=75.0n sa1=75.0n sa2=75.0n sa3=75.0n sa4=75.0n sb1=75.0n sb2=75.0n sb3=75.0n spa=100n spa1=100n spa2=100n spa3=100n sap=91.9776n sapb=114.444n spba=115.715n spba1=117.043n dfm_flag=0 _ccoflag=1 _rcoflag=1 _rgflag=1 spmt=1.11111e+15 spomt=0 spomt1=1.11111e+60 spmb=1.11111e+15 spomb=0 spomb1=1.11111e+60
XT2m1 (X_s2_m X_vb 0 0) nmos_lvt l=60n w=3u multi=1 nf=1 sd=100n ad=2.25e-13 as=2.25e-13 pd=6.15u ps=6.15u nrd=0.096480 nrs=0.096480 sa=75.0n sb=75.0n sa1=75.0n sa2=75.0n sa3=75.0n sa4=75.0n sb1=75.0n sb2=75.0n sb3=75.0n spa=100n spa1=100n spa2=100n spa3=100n sap=91.9776n sapb=120.93n spba=121.82n spba1=124.403n dfm_flag=0 _ccoflag=1 _rcoflag=1 _rgflag=1 spmt=1.11111e+15 spomt=0 spomt1=1.11111e+60 spmb=1.11111e+15 spomb=0 spomb1=1.11111e+60
XM2m2 (X_o_m X_c_m X_s2_m 0) nmos_lvt l=30n w=3u multi=1 nf=1 sd=100n ad=2.25e-13 as=2.25e-13 pd=6.15u ps=6.15u nrd=0.096480 nrs=0.096480 sa=75.0n sb=75.0n sa1=75.0n sa2=75.0n sa3=75.0n sa4=75.0n sb1=75.0n sb2=75.0n sb3=75.0n spa=100n spa1=100n spa2=100n spa3=100n sap=91.9776n sapb=114.444n spba=115.715n spba1=117.043n dfm_flag=0 _ccoflag=1 _rcoflag=1 _rgflag=1 spmt=1.11111e+15 spomt=0 spomt1=1.11111e+60 spmb=1.11111e+15 spomb=0 spomb1=1.11111e+60
XT2m2 (X_s2_m X_vb 0 0) nmos_lvt l=60n w=3u multi=1 nf=1 sd=100n ad=2.25e-13 as=2.25e-13 pd=6.15u ps=6.15u nrd=0.096480 nrs=0.096480 sa=75.0n sb=75.0n sa1=75.0n sa2=75.0n sa3=75.0n sa4=75.0n sb1=75.0n sb2=75.0n sb3=75.0n spa=100n spa1=100n spa2=100n spa3=100n sap=91.9776n sapb=120.93n spba=121.82n spba1=124.403n dfm_flag=0 _ccoflag=1 _rcoflag=1 _rgflag=1 spmt=1.11111e+15 spomt=0 spomt1=1.11111e+60 spmb=1.11111e+15 spomb=0 spomb1=1.11111e+60
XM2m3 (X_o_m X_c_m X_s2_m 0) nmos_lvt l=30n w=3u multi=1 nf=1 sd=100n ad=2.25e-13 as=2.25e-13 pd=6.15u ps=6.15u nrd=0.096480 nrs=0.096480 sa=75.0n sb=75.0n sa1=75.0n sa2=75.0n sa3=75.0n sa4=75.0n sb1=75.0n sb2=75.0n sb3=75.0n spa=100n spa1=100n spa2=100n spa3=100n sap=91.9776n sapb=114.444n spba=115.715n spba1=117.043n dfm_flag=0 _ccoflag=1 _rcoflag=1 _rgflag=1 spmt=1.11111e+15 spomt=0 spomt1=1.11111e+60 spmb=1.11111e+15 spomb=0 spomb1=1.11111e+60
XT2m3 (X_s2_m X_vb 0 0) nmos_lvt l=60n w=3u multi=1 nf=1 sd=100n ad=2.25e-13 as=2.25e-13 pd=6.15u ps=6.15u nrd=0.096480 nrs=0.096480 sa=75.0n sb=75.0n sa1=75.0n sa2=75.0n sa3=75.0n sa4=75.0n sb1=75.0n sb2=75.0n sb3=75.0n spa=100n spa1=100n spa2=100n spa3=100n sap=91.9776n sapb=120.93n spba=121.82n spba1=124.403n dfm_flag=0 _ccoflag=1 _rcoflag=1 _rgflag=1 spmt=1.11111e+15 spomt=0 spomt1=1.11111e+60 spmb=1.11111e+15 spomb=0 spomb1=1.11111e+60
XM2m4 (X_o_m X_c_m X_s2_m 0) nmos_lvt l=30n w=3u multi=1 nf=1 sd=100n ad=2.25e-13 as=2.25e-13 pd=6.15u ps=6.15u nrd=0.096480 nrs=0.096480 sa=75.0n sb=75.0n sa1=75.0n sa2=75.0n sa3=75.0n sa4=75.0n sb1=75.0n sb2=75.0n sb3=75.0n spa=100n spa1=100n spa2=100n spa3=100n sap=91.9776n sapb=114.444n spba=115.715n spba1=117.043n dfm_flag=0 _ccoflag=1 _rcoflag=1 _rgflag=1 spmt=1.11111e+15 spomt=0 spomt1=1.11111e+60 spmb=1.11111e+15 spomb=0 spomb1=1.11111e+60
XT2m4 (X_s2_m X_vb 0 0) nmos_lvt l=60n w=3u multi=1 nf=1 sd=100n ad=2.25e-13 as=2.25e-13 pd=6.15u ps=6.15u nrd=0.096480 nrs=0.096480 sa=75.0n sb=75.0n sa1=75.0n sa2=75.0n sa3=75.0n sa4=75.0n sb1=75.0n sb2=75.0n sb3=75.0n spa=100n spa1=100n spa2=100n spa3=100n sap=91.9776n sapb=120.93n spba=121.82n spba1=124.403n dfm_flag=0 _ccoflag=1 _rcoflag=1 _rgflag=1 spmt=1.11111e+15 spomt=0 spomt1=1.11111e+60 spmb=1.11111e+15 spomb=0 spomb1=1.11111e+60
XM2m5 (X_o_m X_c_m X_s2_m 0) nmos_lvt l=30n w=3u multi=1 nf=1 sd=100n ad=2.25e-13 as=2.25e-13 pd=6.15u ps=6.15u nrd=0.096480 nrs=0.096480 sa=75.0n sb=75.0n sa1=75.0n sa2=75.0n sa3=75.0n sa4=75.0n sb1=75.0n sb2=75.0n sb3=75.0n spa=100n spa1=100n spa2=100n spa3=100n sap=91.9776n sapb=114.444n spba=115.715n spba1=117.043n dfm_flag=0 _ccoflag=1 _rcoflag=1 _rgflag=1 spmt=1.11111e+15 spomt=0 spomt1=1.11111e+60 spmb=1.11111e+15 spomb=0 spomb1=1.11111e+60
XT2m5 (X_s2_m X_vb 0 0) nmos_lvt l=60n w=3u multi=1 nf=1 sd=100n ad=2.25e-13 as=2.25e-13 pd=6.15u ps=6.15u nrd=0.096480 nrs=0.096480 sa=75.0n sb=75.0n sa1=75.0n sa2=75.0n sa3=75.0n sa4=75.0n sb1=75.0n sb2=75.0n sb3=75.0n spa=100n spa1=100n spa2=100n spa3=100n sap=91.9776n sapb=120.93n spba=121.82n spba1=124.403n dfm_flag=0 _ccoflag=1 _rcoflag=1 _rgflag=1 spmt=1.11111e+15 spomt=0 spomt1=1.11111e+60 spmb=1.11111e+15 spomb=0 spomb1=1.11111e+60
XM2m6 (X_o_m X_c_m X_s2_m 0) nmos_lvt l=30n w=3u multi=1 nf=1 sd=100n ad=2.25e-13 as=2.25e-13 pd=6.15u ps=6.15u nrd=0.096480 nrs=0.096480 sa=75.0n sb=75.0n sa1=75.0n sa2=75.0n sa3=75.0n sa4=75.0n sb1=75.0n sb2=75.0n sb3=75.0n spa=100n spa1=100n spa2=100n spa3=100n sap=91.9776n sapb=114.444n spba=115.715n spba1=117.043n dfm_flag=0 _ccoflag=1 _rcoflag=1 _rgflag=1 spmt=1.11111e+15 spomt=0 spomt1=1.11111e+60 spmb=1.11111e+15 spomb=0 spomb1=1.11111e+60
XT2m6 (X_s2_m X_vb 0 0) nmos_lvt l=60n w=3u multi=1 nf=1 sd=100n ad=2.25e-13 as=2.25e-13 pd=6.15u ps=6.15u nrd=0.096480 nrs=0.096480 sa=75.0n sb=75.0n sa1=75.0n sa2=75.0n sa3=75.0n sa4=75.0n sb1=75.0n sb2=75.0n sb3=75.0n spa=100n spa1=100n spa2=100n spa3=100n sap=91.9776n sapb=120.93n spba=121.82n spba1=124.403n dfm_flag=0 _ccoflag=1 _rcoflag=1 _rgflag=1 spmt=1.11111e+15 spomt=0 spomt1=1.11111e+60 spmb=1.11111e+15 spomb=0 spomb1=1.11111e+60
XM2m7 (X_o_m X_c_m X_s2_m 0) nmos_lvt l=30n w=3u multi=1 nf=1 sd=100n ad=2.25e-13 as=2.25e-13 pd=6.15u ps=6.15u nrd=0.096480 nrs=0.096480 sa=75.0n sb=75.0n sa1=75.0n sa2=75.0n sa3=75.0n sa4=75.0n sb1=75.0n sb2=75.0n sb3=75.0n spa=100n spa1=100n spa2=100n spa3=100n sap=91.9776n sapb=114.444n spba=115.715n spba1=117.043n dfm_flag=0 _ccoflag=1 _rcoflag=1 _rgflag=1 spmt=1.11111e+15 spomt=0 spomt1=1.11111e+60 spmb=1.11111e+15 spomb=0 spomb1=1.11111e+60
XT2m7 (X_s2_m X_vb 0 0) nmos_lvt l=60n w=3u multi=1 nf=1 sd=100n ad=2.25e-13 as=2.25e-13 pd=6.15u ps=6.15u nrd=0.096480 nrs=0.096480 sa=75.0n sb=75.0n sa1=75.0n sa2=75.0n sa3=75.0n sa4=75.0n sb1=75.0n sb2=75.0n sb3=75.0n spa=100n spa1=100n spa2=100n spa3=100n sap=91.9776n sapb=120.93n spba=121.82n spba1=124.403n dfm_flag=0 _ccoflag=1 _rcoflag=1 _rgflag=1 spmt=1.11111e+15 spomt=0 spomt1=1.11111e+60 spmb=1.11111e+15 spomb=0 spomb1=1.11111e+60
XRdeg2 (X_s2_p X_s2_m) resistor r=250
XCdeg2 (X_s2_p X_s2_m) capacitor c=1e-13
XCK0 (X_ck0 0) vsource type=pulse val0=0 val1=0.9 delay=1.022321428571429e-10 rise=1e-12 fall=1e-12 width=3.47143e-11 period=7.14286e-11
XKB0 (X_kb0 0) vsource type=pulse val0=0.9 val1=0 delay=1.022321428571429e-10 rise=1e-12 fall=1e-12 width=3.47143e-11 period=7.14286e-11
XSN0p (X_h0p X_ck0 X_o_p 0) nmos_lvt l=30n w=3u multi=1 nf=1 sd=100n ad=2.25e-13 as=2.25e-13 pd=6.15u ps=6.15u nrd=0.096480 nrs=0.096480 sa=75.0n sb=75.0n sa1=75.0n sa2=75.0n sa3=75.0n sa4=75.0n sb1=75.0n sb2=75.0n sb3=75.0n spa=100n spa1=100n spa2=100n spa3=100n sap=91.9776n sapb=114.444n spba=115.715n spba1=117.043n dfm_flag=0 _ccoflag=1 _rcoflag=1 _rgflag=1 spmt=1.11111e+15 spomt=0 spomt1=1.11111e+60 spmb=1.11111e+15 spomb=0 spomb1=1.11111e+60
XSP0p (X_h0p X_kb0 X_o_p X_vdd) pmos_lvt l=30n w=3u multi=1 nf=1 sd=100n ad=2.25e-13 as=2.25e-13 pd=6.15u ps=6.15u nrd=0.055246 nrs=0.055246 sa=75.0n sb=75.0n sa1=75.0n sa2=75.0n sa3=75.0n sa4=75.0n sb1=75.0n sb2=75.0n sb3=75.0n spa=100n spa1=100n spa2=100n spa3=100n sap=91.9776n sapb=114.444n spba=115.715n spba1=117.043n dfm_flag=0 _ccoflag=1 _rcoflag=1 _rgflag=1 spmt=1.11111e+15 spomt=0 spomt1=1.11111e+60 spmb=1.11111e+15 spomb=0 spomb1=1.11111e+60
XCH0p (X_h0p 0) capacitor c=5e-15
XRH0p (X_h0p X_o_p) resistor r=1T
XSN0m (X_h0m X_ck0 X_o_m 0) nmos_lvt l=30n w=3u multi=1 nf=1 sd=100n ad=2.25e-13 as=2.25e-13 pd=6.15u ps=6.15u nrd=0.096480 nrs=0.096480 sa=75.0n sb=75.0n sa1=75.0n sa2=75.0n sa3=75.0n sa4=75.0n sb1=75.0n sb2=75.0n sb3=75.0n spa=100n spa1=100n spa2=100n spa3=100n sap=91.9776n sapb=114.444n spba=115.715n spba1=117.043n dfm_flag=0 _ccoflag=1 _rcoflag=1 _rgflag=1 spmt=1.11111e+15 spomt=0 spomt1=1.11111e+60 spmb=1.11111e+15 spomb=0 spomb1=1.11111e+60
XSP0m (X_h0m X_kb0 X_o_m X_vdd) pmos_lvt l=30n w=3u multi=1 nf=1 sd=100n ad=2.25e-13 as=2.25e-13 pd=6.15u ps=6.15u nrd=0.055246 nrs=0.055246 sa=75.0n sb=75.0n sa1=75.0n sa2=75.0n sa3=75.0n sa4=75.0n sb1=75.0n sb2=75.0n sb3=75.0n spa=100n spa1=100n spa2=100n spa3=100n sap=91.9776n sapb=114.444n spba=115.715n spba1=117.043n dfm_flag=0 _ccoflag=1 _rcoflag=1 _rgflag=1 spmt=1.11111e+15 spomt=0 spomt1=1.11111e+60 spmb=1.11111e+15 spomb=0 spomb1=1.11111e+60
XCH0m (X_h0m 0) capacitor c=5e-15
XRH0m (X_h0m X_o_m) resistor r=1T
XCK1 (X_ck1 0) vsource type=pulse val0=0 val1=0.9 delay=1.111611428571429e-10 rise=1e-12 fall=1e-12 width=3.47143e-11 period=7.14286e-11
XKB1 (X_kb1 0) vsource type=pulse val0=0.9 val1=0 delay=1.111611428571429e-10 rise=1e-12 fall=1e-12 width=3.47143e-11 period=7.14286e-11
XSN1p (X_h1p X_ck1 X_o_p 0) nmos_lvt l=30n w=3u multi=1 nf=1 sd=100n ad=2.25e-13 as=2.25e-13 pd=6.15u ps=6.15u nrd=0.096480 nrs=0.096480 sa=75.0n sb=75.0n sa1=75.0n sa2=75.0n sa3=75.0n sa4=75.0n sb1=75.0n sb2=75.0n sb3=75.0n spa=100n spa1=100n spa2=100n spa3=100n sap=91.9776n sapb=114.444n spba=115.715n spba1=117.043n dfm_flag=0 _ccoflag=1 _rcoflag=1 _rgflag=1 spmt=1.11111e+15 spomt=0 spomt1=1.11111e+60 spmb=1.11111e+15 spomb=0 spomb1=1.11111e+60
XSP1p (X_h1p X_kb1 X_o_p X_vdd) pmos_lvt l=30n w=3u multi=1 nf=1 sd=100n ad=2.25e-13 as=2.25e-13 pd=6.15u ps=6.15u nrd=0.055246 nrs=0.055246 sa=75.0n sb=75.0n sa1=75.0n sa2=75.0n sa3=75.0n sa4=75.0n sb1=75.0n sb2=75.0n sb3=75.0n spa=100n spa1=100n spa2=100n spa3=100n sap=91.9776n sapb=114.444n spba=115.715n spba1=117.043n dfm_flag=0 _ccoflag=1 _rcoflag=1 _rgflag=1 spmt=1.11111e+15 spomt=0 spomt1=1.11111e+60 spmb=1.11111e+15 spomb=0 spomb1=1.11111e+60
XCH1p (X_h1p 0) capacitor c=5e-15
XRH1p (X_h1p X_o_p) resistor r=1T
XSN1m (X_h1m X_ck1 X_o_m 0) nmos_lvt l=30n w=3u multi=1 nf=1 sd=100n ad=2.25e-13 as=2.25e-13 pd=6.15u ps=6.15u nrd=0.096480 nrs=0.096480 sa=75.0n sb=75.0n sa1=75.0n sa2=75.0n sa3=75.0n sa4=75.0n sb1=75.0n sb2=75.0n sb3=75.0n spa=100n spa1=100n spa2=100n spa3=100n sap=91.9776n sapb=114.444n spba=115.715n spba1=117.043n dfm_flag=0 _ccoflag=1 _rcoflag=1 _rgflag=1 spmt=1.11111e+15 spomt=0 spomt1=1.11111e+60 spmb=1.11111e+15 spomb=0 spomb1=1.11111e+60
XSP1m (X_h1m X_kb1 X_o_m X_vdd) pmos_lvt l=30n w=3u multi=1 nf=1 sd=100n ad=2.25e-13 as=2.25e-13 pd=6.15u ps=6.15u nrd=0.055246 nrs=0.055246 sa=75.0n sb=75.0n sa1=75.0n sa2=75.0n sa3=75.0n sa4=75.0n sb1=75.0n sb2=75.0n sb3=75.0n spa=100n spa1=100n spa2=100n spa3=100n sap=91.9776n sapb=114.444n spba=115.715n spba1=117.043n dfm_flag=0 _ccoflag=1 _rcoflag=1 _rgflag=1 spmt=1.11111e+15 spomt=0 spomt1=1.11111e+60 spmb=1.11111e+15 spomb=0 spomb1=1.11111e+60
XCH1m (X_h1m 0) capacitor c=5e-15
XRH1m (X_h1m X_o_m) resistor r=1T
XCK2 (X_ck2 0) vsource type=pulse val0=0 val1=0.9 delay=1.200891428571429e-10 rise=1e-12 fall=1e-12 width=3.47143e-11 period=7.14286e-11
XKB2 (X_kb2 0) vsource type=pulse val0=0.9 val1=0 delay=1.200891428571429e-10 rise=1e-12 fall=1e-12 width=3.47143e-11 period=7.14286e-11
XSN2p (X_h2p X_ck2 X_o_p 0) nmos_lvt l=30n w=3u multi=1 nf=1 sd=100n ad=2.25e-13 as=2.25e-13 pd=6.15u ps=6.15u nrd=0.096480 nrs=0.096480 sa=75.0n sb=75.0n sa1=75.0n sa2=75.0n sa3=75.0n sa4=75.0n sb1=75.0n sb2=75.0n sb3=75.0n spa=100n spa1=100n spa2=100n spa3=100n sap=91.9776n sapb=114.444n spba=115.715n spba1=117.043n dfm_flag=0 _ccoflag=1 _rcoflag=1 _rgflag=1 spmt=1.11111e+15 spomt=0 spomt1=1.11111e+60 spmb=1.11111e+15 spomb=0 spomb1=1.11111e+60
XSP2p (X_h2p X_kb2 X_o_p X_vdd) pmos_lvt l=30n w=3u multi=1 nf=1 sd=100n ad=2.25e-13 as=2.25e-13 pd=6.15u ps=6.15u nrd=0.055246 nrs=0.055246 sa=75.0n sb=75.0n sa1=75.0n sa2=75.0n sa3=75.0n sa4=75.0n sb1=75.0n sb2=75.0n sb3=75.0n spa=100n spa1=100n spa2=100n spa3=100n sap=91.9776n sapb=114.444n spba=115.715n spba1=117.043n dfm_flag=0 _ccoflag=1 _rcoflag=1 _rgflag=1 spmt=1.11111e+15 spomt=0 spomt1=1.11111e+60 spmb=1.11111e+15 spomb=0 spomb1=1.11111e+60
XCH2p (X_h2p 0) capacitor c=5e-15
XRH2p (X_h2p X_o_p) resistor r=1T
XSN2m (X_h2m X_ck2 X_o_m 0) nmos_lvt l=30n w=3u multi=1 nf=1 sd=100n ad=2.25e-13 as=2.25e-13 pd=6.15u ps=6.15u nrd=0.096480 nrs=0.096480 sa=75.0n sb=75.0n sa1=75.0n sa2=75.0n sa3=75.0n sa4=75.0n sb1=75.0n sb2=75.0n sb3=75.0n spa=100n spa1=100n spa2=100n spa3=100n sap=91.9776n sapb=114.444n spba=115.715n spba1=117.043n dfm_flag=0 _ccoflag=1 _rcoflag=1 _rgflag=1 spmt=1.11111e+15 spomt=0 spomt1=1.11111e+60 spmb=1.11111e+15 spomb=0 spomb1=1.11111e+60
XSP2m (X_h2m X_kb2 X_o_m X_vdd) pmos_lvt l=30n w=3u multi=1 nf=1 sd=100n ad=2.25e-13 as=2.25e-13 pd=6.15u ps=6.15u nrd=0.055246 nrs=0.055246 sa=75.0n sb=75.0n sa1=75.0n sa2=75.0n sa3=75.0n sa4=75.0n sb1=75.0n sb2=75.0n sb3=75.0n spa=100n spa1=100n spa2=100n spa3=100n sap=91.9776n sapb=114.444n spba=115.715n spba1=117.043n dfm_flag=0 _ccoflag=1 _rcoflag=1 _rgflag=1 spmt=1.11111e+15 spomt=0 spomt1=1.11111e+60 spmb=1.11111e+15 spomb=0 spomb1=1.11111e+60
XCH2m (X_h2m 0) capacitor c=5e-15
XRH2m (X_h2m X_o_m) resistor r=1T
XCK3 (X_ck3 0) vsource type=pulse val0=0 val1=0.9 delay=1.290181428571429e-10 rise=1e-12 fall=1e-12 width=3.47143e-11 period=7.14286e-11
XKB3 (X_kb3 0) vsource type=pulse val0=0.9 val1=0 delay=1.290181428571429e-10 rise=1e-12 fall=1e-12 width=3.47143e-11 period=7.14286e-11
XSN3p (X_h3p X_ck3 X_o_p 0) nmos_lvt l=30n w=3u multi=1 nf=1 sd=100n ad=2.25e-13 as=2.25e-13 pd=6.15u ps=6.15u nrd=0.096480 nrs=0.096480 sa=75.0n sb=75.0n sa1=75.0n sa2=75.0n sa3=75.0n sa4=75.0n sb1=75.0n sb2=75.0n sb3=75.0n spa=100n spa1=100n spa2=100n spa3=100n sap=91.9776n sapb=114.444n spba=115.715n spba1=117.043n dfm_flag=0 _ccoflag=1 _rcoflag=1 _rgflag=1 spmt=1.11111e+15 spomt=0 spomt1=1.11111e+60 spmb=1.11111e+15 spomb=0 spomb1=1.11111e+60
XSP3p (X_h3p X_kb3 X_o_p X_vdd) pmos_lvt l=30n w=3u multi=1 nf=1 sd=100n ad=2.25e-13 as=2.25e-13 pd=6.15u ps=6.15u nrd=0.055246 nrs=0.055246 sa=75.0n sb=75.0n sa1=75.0n sa2=75.0n sa3=75.0n sa4=75.0n sb1=75.0n sb2=75.0n sb3=75.0n spa=100n spa1=100n spa2=100n spa3=100n sap=91.9776n sapb=114.444n spba=115.715n spba1=117.043n dfm_flag=0 _ccoflag=1 _rcoflag=1 _rgflag=1 spmt=1.11111e+15 spomt=0 spomt1=1.11111e+60 spmb=1.11111e+15 spomb=0 spomb1=1.11111e+60
XCH3p (X_h3p 0) capacitor c=5e-15
XRH3p (X_h3p X_o_p) resistor r=1T
XSN3m (X_h3m X_ck3 X_o_m 0) nmos_lvt l=30n w=3u multi=1 nf=1 sd=100n ad=2.25e-13 as=2.25e-13 pd=6.15u ps=6.15u nrd=0.096480 nrs=0.096480 sa=75.0n sb=75.0n sa1=75.0n sa2=75.0n sa3=75.0n sa4=75.0n sb1=75.0n sb2=75.0n sb3=75.0n spa=100n spa1=100n spa2=100n spa3=100n sap=91.9776n sapb=114.444n spba=115.715n spba1=117.043n dfm_flag=0 _ccoflag=1 _rcoflag=1 _rgflag=1 spmt=1.11111e+15 spomt=0 spomt1=1.11111e+60 spmb=1.11111e+15 spomb=0 spomb1=1.11111e+60
XSP3m (X_h3m X_kb3 X_o_m X_vdd) pmos_lvt l=30n w=3u multi=1 nf=1 sd=100n ad=2.25e-13 as=2.25e-13 pd=6.15u ps=6.15u nrd=0.055246 nrs=0.055246 sa=75.0n sb=75.0n sa1=75.0n sa2=75.0n sa3=75.0n sa4=75.0n sb1=75.0n sb2=75.0n sb3=75.0n spa=100n spa1=100n spa2=100n spa3=100n sap=91.9776n sapb=114.444n spba=115.715n spba1=117.043n dfm_flag=0 _ccoflag=1 _rcoflag=1 _rgflag=1 spmt=1.11111e+15 spomt=0 spomt1=1.11111e+60 spmb=1.11111e+15 spomb=0 spomb1=1.11111e+60
XCH3m (X_h3m 0) capacitor c=5e-15
XRH3m (X_h3m X_o_m) resistor r=1T
XCK4 (X_ck4 0) vsource type=pulse val0=0 val1=0.9 delay=1.379461428571429e-10 rise=1e-12 fall=1e-12 width=3.47143e-11 period=7.14286e-11
XKB4 (X_kb4 0) vsource type=pulse val0=0.9 val1=0 delay=1.379461428571429e-10 rise=1e-12 fall=1e-12 width=3.47143e-11 period=7.14286e-11
XSN4p (X_h4p X_ck4 X_o_p 0) nmos_lvt l=30n w=3u multi=1 nf=1 sd=100n ad=2.25e-13 as=2.25e-13 pd=6.15u ps=6.15u nrd=0.096480 nrs=0.096480 sa=75.0n sb=75.0n sa1=75.0n sa2=75.0n sa3=75.0n sa4=75.0n sb1=75.0n sb2=75.0n sb3=75.0n spa=100n spa1=100n spa2=100n spa3=100n sap=91.9776n sapb=114.444n spba=115.715n spba1=117.043n dfm_flag=0 _ccoflag=1 _rcoflag=1 _rgflag=1 spmt=1.11111e+15 spomt=0 spomt1=1.11111e+60 spmb=1.11111e+15 spomb=0 spomb1=1.11111e+60
XSP4p (X_h4p X_kb4 X_o_p X_vdd) pmos_lvt l=30n w=3u multi=1 nf=1 sd=100n ad=2.25e-13 as=2.25e-13 pd=6.15u ps=6.15u nrd=0.055246 nrs=0.055246 sa=75.0n sb=75.0n sa1=75.0n sa2=75.0n sa3=75.0n sa4=75.0n sb1=75.0n sb2=75.0n sb3=75.0n spa=100n spa1=100n spa2=100n spa3=100n sap=91.9776n sapb=114.444n spba=115.715n spba1=117.043n dfm_flag=0 _ccoflag=1 _rcoflag=1 _rgflag=1 spmt=1.11111e+15 spomt=0 spomt1=1.11111e+60 spmb=1.11111e+15 spomb=0 spomb1=1.11111e+60
XCH4p (X_h4p 0) capacitor c=5e-15
XRH4p (X_h4p X_o_p) resistor r=1T
XSN4m (X_h4m X_ck4 X_o_m 0) nmos_lvt l=30n w=3u multi=1 nf=1 sd=100n ad=2.25e-13 as=2.25e-13 pd=6.15u ps=6.15u nrd=0.096480 nrs=0.096480 sa=75.0n sb=75.0n sa1=75.0n sa2=75.0n sa3=75.0n sa4=75.0n sb1=75.0n sb2=75.0n sb3=75.0n spa=100n spa1=100n spa2=100n spa3=100n sap=91.9776n sapb=114.444n spba=115.715n spba1=117.043n dfm_flag=0 _ccoflag=1 _rcoflag=1 _rgflag=1 spmt=1.11111e+15 spomt=0 spomt1=1.11111e+60 spmb=1.11111e+15 spomb=0 spomb1=1.11111e+60
XSP4m (X_h4m X_kb4 X_o_m X_vdd) pmos_lvt l=30n w=3u multi=1 nf=1 sd=100n ad=2.25e-13 as=2.25e-13 pd=6.15u ps=6.15u nrd=0.055246 nrs=0.055246 sa=75.0n sb=75.0n sa1=75.0n sa2=75.0n sa3=75.0n sa4=75.0n sb1=75.0n sb2=75.0n sb3=75.0n spa=100n spa1=100n spa2=100n spa3=100n sap=91.9776n sapb=114.444n spba=115.715n spba1=117.043n dfm_flag=0 _ccoflag=1 _rcoflag=1 _rgflag=1 spmt=1.11111e+15 spomt=0 spomt1=1.11111e+60 spmb=1.11111e+15 spomb=0 spomb1=1.11111e+60
XCH4m (X_h4m 0) capacitor c=5e-15
XRH4m (X_h4m X_o_m) resistor r=1T
XCK5 (X_ck5 0) vsource type=pulse val0=0 val1=0.9 delay=1.468751428571429e-10 rise=1e-12 fall=1e-12 width=3.47143e-11 period=7.14286e-11
XKB5 (X_kb5 0) vsource type=pulse val0=0.9 val1=0 delay=1.468751428571429e-10 rise=1e-12 fall=1e-12 width=3.47143e-11 period=7.14286e-11
XSN5p (X_h5p X_ck5 X_o_p 0) nmos_lvt l=30n w=3u multi=1 nf=1 sd=100n ad=2.25e-13 as=2.25e-13 pd=6.15u ps=6.15u nrd=0.096480 nrs=0.096480 sa=75.0n sb=75.0n sa1=75.0n sa2=75.0n sa3=75.0n sa4=75.0n sb1=75.0n sb2=75.0n sb3=75.0n spa=100n spa1=100n spa2=100n spa3=100n sap=91.9776n sapb=114.444n spba=115.715n spba1=117.043n dfm_flag=0 _ccoflag=1 _rcoflag=1 _rgflag=1 spmt=1.11111e+15 spomt=0 spomt1=1.11111e+60 spmb=1.11111e+15 spomb=0 spomb1=1.11111e+60
XSP5p (X_h5p X_kb5 X_o_p X_vdd) pmos_lvt l=30n w=3u multi=1 nf=1 sd=100n ad=2.25e-13 as=2.25e-13 pd=6.15u ps=6.15u nrd=0.055246 nrs=0.055246 sa=75.0n sb=75.0n sa1=75.0n sa2=75.0n sa3=75.0n sa4=75.0n sb1=75.0n sb2=75.0n sb3=75.0n spa=100n spa1=100n spa2=100n spa3=100n sap=91.9776n sapb=114.444n spba=115.715n spba1=117.043n dfm_flag=0 _ccoflag=1 _rcoflag=1 _rgflag=1 spmt=1.11111e+15 spomt=0 spomt1=1.11111e+60 spmb=1.11111e+15 spomb=0 spomb1=1.11111e+60
XCH5p (X_h5p 0) capacitor c=5e-15
XRH5p (X_h5p X_o_p) resistor r=1T
XSN5m (X_h5m X_ck5 X_o_m 0) nmos_lvt l=30n w=3u multi=1 nf=1 sd=100n ad=2.25e-13 as=2.25e-13 pd=6.15u ps=6.15u nrd=0.096480 nrs=0.096480 sa=75.0n sb=75.0n sa1=75.0n sa2=75.0n sa3=75.0n sa4=75.0n sb1=75.0n sb2=75.0n sb3=75.0n spa=100n spa1=100n spa2=100n spa3=100n sap=91.9776n sapb=114.444n spba=115.715n spba1=117.043n dfm_flag=0 _ccoflag=1 _rcoflag=1 _rgflag=1 spmt=1.11111e+15 spomt=0 spomt1=1.11111e+60 spmb=1.11111e+15 spomb=0 spomb1=1.11111e+60
XSP5m (X_h5m X_kb5 X_o_m X_vdd) pmos_lvt l=30n w=3u multi=1 nf=1 sd=100n ad=2.25e-13 as=2.25e-13 pd=6.15u ps=6.15u nrd=0.055246 nrs=0.055246 sa=75.0n sb=75.0n sa1=75.0n sa2=75.0n sa3=75.0n sa4=75.0n sb1=75.0n sb2=75.0n sb3=75.0n spa=100n spa1=100n spa2=100n spa3=100n sap=91.9776n sapb=114.444n spba=115.715n spba1=117.043n dfm_flag=0 _ccoflag=1 _rcoflag=1 _rgflag=1 spmt=1.11111e+15 spomt=0 spomt1=1.11111e+60 spmb=1.11111e+15 spomb=0 spomb1=1.11111e+60
XCH5m (X_h5m 0) capacitor c=5e-15
XRH5m (X_h5m X_o_m) resistor r=1T
XCK6 (X_ck6 0) vsource type=pulse val0=0 val1=0.9 delay=1.558031428571429e-10 rise=1e-12 fall=1e-12 width=3.47143e-11 period=7.14286e-11
XKB6 (X_kb6 0) vsource type=pulse val0=0.9 val1=0 delay=1.558031428571429e-10 rise=1e-12 fall=1e-12 width=3.47143e-11 period=7.14286e-11
XSN6p (X_h6p X_ck6 X_o_p 0) nmos_lvt l=30n w=3u multi=1 nf=1 sd=100n ad=2.25e-13 as=2.25e-13 pd=6.15u ps=6.15u nrd=0.096480 nrs=0.096480 sa=75.0n sb=75.0n sa1=75.0n sa2=75.0n sa3=75.0n sa4=75.0n sb1=75.0n sb2=75.0n sb3=75.0n spa=100n spa1=100n spa2=100n spa3=100n sap=91.9776n sapb=114.444n spba=115.715n spba1=117.043n dfm_flag=0 _ccoflag=1 _rcoflag=1 _rgflag=1 spmt=1.11111e+15 spomt=0 spomt1=1.11111e+60 spmb=1.11111e+15 spomb=0 spomb1=1.11111e+60
XSP6p (X_h6p X_kb6 X_o_p X_vdd) pmos_lvt l=30n w=3u multi=1 nf=1 sd=100n ad=2.25e-13 as=2.25e-13 pd=6.15u ps=6.15u nrd=0.055246 nrs=0.055246 sa=75.0n sb=75.0n sa1=75.0n sa2=75.0n sa3=75.0n sa4=75.0n sb1=75.0n sb2=75.0n sb3=75.0n spa=100n spa1=100n spa2=100n spa3=100n sap=91.9776n sapb=114.444n spba=115.715n spba1=117.043n dfm_flag=0 _ccoflag=1 _rcoflag=1 _rgflag=1 spmt=1.11111e+15 spomt=0 spomt1=1.11111e+60 spmb=1.11111e+15 spomb=0 spomb1=1.11111e+60
XCH6p (X_h6p 0) capacitor c=5e-15
XRH6p (X_h6p X_o_p) resistor r=1T
XSN6m (X_h6m X_ck6 X_o_m 0) nmos_lvt l=30n w=3u multi=1 nf=1 sd=100n ad=2.25e-13 as=2.25e-13 pd=6.15u ps=6.15u nrd=0.096480 nrs=0.096480 sa=75.0n sb=75.0n sa1=75.0n sa2=75.0n sa3=75.0n sa4=75.0n sb1=75.0n sb2=75.0n sb3=75.0n spa=100n spa1=100n spa2=100n spa3=100n sap=91.9776n sapb=114.444n spba=115.715n spba1=117.043n dfm_flag=0 _ccoflag=1 _rcoflag=1 _rgflag=1 spmt=1.11111e+15 spomt=0 spomt1=1.11111e+60 spmb=1.11111e+15 spomb=0 spomb1=1.11111e+60
XSP6m (X_h6m X_kb6 X_o_m X_vdd) pmos_lvt l=30n w=3u multi=1 nf=1 sd=100n ad=2.25e-13 as=2.25e-13 pd=6.15u ps=6.15u nrd=0.055246 nrs=0.055246 sa=75.0n sb=75.0n sa1=75.0n sa2=75.0n sa3=75.0n sa4=75.0n sb1=75.0n sb2=75.0n sb3=75.0n spa=100n spa1=100n spa2=100n spa3=100n sap=91.9776n sapb=114.444n spba=115.715n spba1=117.043n dfm_flag=0 _ccoflag=1 _rcoflag=1 _rgflag=1 spmt=1.11111e+15 spomt=0 spomt1=1.11111e+60 spmb=1.11111e+15 spomb=0 spomb1=1.11111e+60
XCH6m (X_h6m 0) capacitor c=5e-15
XRH6m (X_h6m X_o_m) resistor r=1T
XCK7 (X_ck7 0) vsource type=pulse val0=0 val1=0.9 delay=1.647321428571429e-10 rise=1e-12 fall=1e-12 width=3.47143e-11 period=7.14286e-11
XKB7 (X_kb7 0) vsource type=pulse val0=0.9 val1=0 delay=1.647321428571429e-10 rise=1e-12 fall=1e-12 width=3.47143e-11 period=7.14286e-11
XSN7p (X_h7p X_ck7 X_o_p 0) nmos_lvt l=30n w=3u multi=1 nf=1 sd=100n ad=2.25e-13 as=2.25e-13 pd=6.15u ps=6.15u nrd=0.096480 nrs=0.096480 sa=75.0n sb=75.0n sa1=75.0n sa2=75.0n sa3=75.0n sa4=75.0n sb1=75.0n sb2=75.0n sb3=75.0n spa=100n spa1=100n spa2=100n spa3=100n sap=91.9776n sapb=114.444n spba=115.715n spba1=117.043n dfm_flag=0 _ccoflag=1 _rcoflag=1 _rgflag=1 spmt=1.11111e+15 spomt=0 spomt1=1.11111e+60 spmb=1.11111e+15 spomb=0 spomb1=1.11111e+60
XSP7p (X_h7p X_kb7 X_o_p X_vdd) pmos_lvt l=30n w=3u multi=1 nf=1 sd=100n ad=2.25e-13 as=2.25e-13 pd=6.15u ps=6.15u nrd=0.055246 nrs=0.055246 sa=75.0n sb=75.0n sa1=75.0n sa2=75.0n sa3=75.0n sa4=75.0n sb1=75.0n sb2=75.0n sb3=75.0n spa=100n spa1=100n spa2=100n spa3=100n sap=91.9776n sapb=114.444n spba=115.715n spba1=117.043n dfm_flag=0 _ccoflag=1 _rcoflag=1 _rgflag=1 spmt=1.11111e+15 spomt=0 spomt1=1.11111e+60 spmb=1.11111e+15 spomb=0 spomb1=1.11111e+60
XCH7p (X_h7p 0) capacitor c=5e-15
XRH7p (X_h7p X_o_p) resistor r=1T
XSN7m (X_h7m X_ck7 X_o_m 0) nmos_lvt l=30n w=3u multi=1 nf=1 sd=100n ad=2.25e-13 as=2.25e-13 pd=6.15u ps=6.15u nrd=0.096480 nrs=0.096480 sa=75.0n sb=75.0n sa1=75.0n sa2=75.0n sa3=75.0n sa4=75.0n sb1=75.0n sb2=75.0n sb3=75.0n spa=100n spa1=100n spa2=100n spa3=100n sap=91.9776n sapb=114.444n spba=115.715n spba1=117.043n dfm_flag=0 _ccoflag=1 _rcoflag=1 _rgflag=1 spmt=1.11111e+15 spomt=0 spomt1=1.11111e+60 spmb=1.11111e+15 spomb=0 spomb1=1.11111e+60
XSP7m (X_h7m X_kb7 X_o_m X_vdd) pmos_lvt l=30n w=3u multi=1 nf=1 sd=100n ad=2.25e-13 as=2.25e-13 pd=6.15u ps=6.15u nrd=0.055246 nrs=0.055246 sa=75.0n sb=75.0n sa1=75.0n sa2=75.0n sa3=75.0n sa4=75.0n sb1=75.0n sb2=75.0n sb3=75.0n spa=100n spa1=100n spa2=100n spa3=100n sap=91.9776n sapb=114.444n spba=115.715n spba1=117.043n dfm_flag=0 _ccoflag=1 _rcoflag=1 _rgflag=1 spmt=1.11111e+15 spomt=0 spomt1=1.11111e+60 spmb=1.11111e+15 spomb=0 spomb1=1.11111e+60
XCH7m (X_h7m 0) capacitor c=5e-15
XRH7m (X_h7m X_o_m) resistor r=1T
PAM4Vp (PAM4_src_p X_cm) vsource type=pwl wave=[ \
 0 -0.03333333333333333 \
 2.089285714285714e-10 -0.03333333333333333 \
 2.099285714285714e-10 0.1 \
 2.178571428571429e-10 0.1 \
 2.188571428571429e-10 -0.03333333333333333 \
 2.267857142857143e-10 -0.03333333333333333 \
 2.277857142857143e-10 0.1 \
 2.357142857142857e-10 0.1 \
 2.367142857142857e-10 0.1 \
 2.446428571428572e-10 0.1 \
 2.456428571428572e-10 0.1 \
 2.535714285714286e-10 0.1 \
 2.545714285714286e-10 0.03333333333333333 \
 2.625e-10 0.03333333333333333 \
 2.635e-10 -0.1 \
 2.714285714285714e-10 -0.1 \
 2.724285714285714e-10 0.1 \
 2.803571428571429e-10 0.1 \
 2.813571428571429e-10 0.03333333333333333 \
 2.892857142857143e-10 0.03333333333333333 \
 2.902857142857143e-10 0.1 \
 2.982142857142857e-10 0.1 \
 2.992142857142857e-10 -0.1 \
 3.071428571428571e-10 -0.1 \
 3.081428571428571e-10 -0.03333333333333333 \
 3.160714285714286e-10 -0.03333333333333333 \
 3.170714285714286e-10 0.1 \
 3.25e-10 0.1 \
 3.26e-10 0.1 \
 3.339285714285715e-10 0.1 \
 3.349285714285715e-10 0.1 \
 3.428571428571429e-10 0.1 \
 3.438571428571429e-10 0.1 \
 3.517857142857143e-10 0.1 \
 3.527857142857143e-10 0.1 \
 3.607142857142857e-10 0.1 \
 3.617142857142857e-10 0.1 \
 3.696428571428572e-10 0.1 \
 3.706428571428572e-10 0.1 \
 3.785714285714286e-10 0.1 \
 3.795714285714286e-10 -0.03333333333333333 \
 3.875e-10 -0.03333333333333333 \
 3.885e-10 -0.03333333333333333 \
 3.964285714285714e-10 -0.03333333333333333 \
 3.974285714285714e-10 -0.03333333333333333 \
 4.053571428571429e-10 -0.03333333333333333 \
 4.063571428571428e-10 -0.1 \
 4.142857142857143e-10 -0.1 \
 4.152857142857143e-10 -0.1 \
 4.232142857142858e-10 -0.1 \
 4.242142857142857e-10 0.1 \
 4.321428571428571e-10 0.1 \
 4.331428571428571e-10 0.03333333333333333 \
 4.410714285714285e-10 0.03333333333333333 \
 4.420714285714285e-10 0.03333333333333333 \
 4.5e-10 0.03333333333333333 \
 4.51e-10 0.1 \
 4.589285714285714e-10 0.1 \
 4.599285714285714e-10 0.03333333333333333 \
 4.678571428571429e-10 0.03333333333333333 \
 4.688571428571429e-10 -0.03333333333333333 \
 4.767857142857142e-10 -0.03333333333333333 \
 4.777857142857142e-10 -0.1 \
 4.857142857142857e-10 -0.1 \
 4.867142857142857e-10 0.03333333333333333 \
 4.946428571428571e-10 0.03333333333333333 \
 4.956428571428571e-10 0.03333333333333333 \
 5.035714285714286e-10 0.03333333333333333 \
 5.045714285714286e-10 0.1 \
 5.125e-10 0.1 \
 5.135e-10 -0.03333333333333333 \
 5.214285714285714e-10 -0.03333333333333333 \
 5.224285714285714e-10 -0.03333333333333333 \
 5.303571428571428e-10 -0.03333333333333333 \
 5.313571428571428e-10 0.03333333333333333 \
 5.392857142857143e-10 0.03333333333333333 \
 5.402857142857143e-10 0.1 \
 5.482142857142857e-10 0.1 \
 5.492142857142857e-10 0.03333333333333333 \
 5.571428571428572e-10 0.03333333333333333 \
 5.581428571428572e-10 -0.1 \
 5.660714285714285e-10 -0.1 \
 5.670714285714285e-10 0.03333333333333333 \
 5.75e-10 0.03333333333333333 \
 5.76e-10 0.1 \
 5.839285714285714e-10 0.1 \
 5.849285714285714e-10 -0.03333333333333333 \
 5.928571428571429e-10 -0.03333333333333333 \
 5.938571428571429e-10 0.03333333333333333 \
 6.017857142857143e-10 0.03333333333333333 \
 6.027857142857143e-10 0.03333333333333333 \
 6.107142857142857e-10 0.03333333333333333 \
 6.117142857142857e-10 -0.03333333333333333 \
 6.196428571428571e-10 -0.03333333333333333 \
 6.206428571428571e-10 -0.1 \
 6.285714285714286e-10 -0.1 \
 6.295714285714286e-10 0.03333333333333333 \
 6.375e-10 0.03333333333333333 \
 6.385e-10 -0.03333333333333333 \
 6.464285714285715e-10 -0.03333333333333333 \
 6.474285714285715e-10 0.1 \
 6.553571428571428e-10 0.1 \
 6.563571428571428e-10 -0.1 \
 6.642857142857143e-10 -0.1 \
 6.652857142857143e-10 -0.03333333333333333 \
 6.732142857142857e-10 -0.03333333333333333 \
 6.742142857142857e-10 -0.03333333333333333 \
 6.821428571428572e-10 -0.03333333333333333 \
 6.831428571428572e-10 -0.1 \
 6.910714285714286e-10 -0.1 \
 6.920714285714286e-10 -0.03333333333333333 \
 7.000000000000001e-10 -0.03333333333333333 \
 7.010000000000001e-10 0.03333333333333333 \
 7.089285714285714e-10 0.03333333333333333 \
 7.099285714285714e-10 -0.1 \
 7.178571428571429e-10 -0.1 \
 7.188571428571429e-10 0.1 \
 7.267857142857143e-10 0.1 \
 7.277857142857143e-10 -0.1 \
 7.357142857142858e-10 -0.1 \
 7.367142857142858e-10 0.1 \
 7.446428571428572e-10 0.1 \
 7.456428571428572e-10 0.03333333333333333 \
 7.535714285714286e-10 0.03333333333333333 \
 7.545714285714286e-10 -0.03333333333333333 \
 7.625e-10 -0.03333333333333333 \
 7.635e-10 -0.03333333333333333 \
 7.714285714285715e-10 -0.03333333333333333 \
 7.724285714285714e-10 -0.1 \
 7.803571428571429e-10 -0.1 \
 7.813571428571429e-10 0.03333333333333333 \
 7.892857142857144e-10 0.03333333333333333 \
 7.902857142857143e-10 -0.03333333333333333 \
 7.982142857142857e-10 -0.03333333333333333 \
 7.992142857142857e-10 -0.1 \
 8.071428571428571e-10 -0.1 \
 8.081428571428571e-10 0.03333333333333333 \
 8.160714285714286e-10 0.03333333333333333 \
 8.170714285714286e-10 -0.1 \
 8.25e-10 -0.1 \
 8.26e-10 -0.1 \
 8.339285714285715e-10 -0.1 \
 8.349285714285715e-10 0.03333333333333333 \
 8.428571428571428e-10 0.03333333333333333 \
 8.438571428571428e-10 0.1 \
 8.517857142857143e-10 0.1 \
 8.527857142857143e-10 0.1 \
 8.607142857142857e-10 0.1 \
 8.617142857142857e-10 0.1 \
 8.696428571428572e-10 0.1 \
 8.706428571428572e-10 -0.03333333333333333 \
 8.785714285714286e-10 -0.03333333333333333 \
 8.795714285714286e-10 0.1 \
 8.875e-10 0.1 \
 8.885e-10 0.03333333333333333 \
 8.964285714285714e-10 0.03333333333333333 \
 8.974285714285714e-10 0.1 \
 9.053571428571429e-10 0.1 \
 9.063571428571429e-10 -0.1 \
 9.142857142857143e-10 -0.1 \
 9.152857142857143e-10 -0.1 \
 9.232142857142858e-10 -0.1 \
 9.242142857142858e-10 -0.1 \
 9.321428571428571e-10 -0.1 \
 9.331428571428572e-10 0.1 \
 9.410714285714286e-10 0.1 \
 9.420714285714287e-10 -0.03333333333333333 \
 9.5e-10 -0.03333333333333333 \
 9.510000000000001e-10 0.1 \
 9.589285714285715e-10 0.1 \
 9.599285714285716e-10 0.03333333333333333 \
 9.678571428571429e-10 0.03333333333333333 \
 9.68857142857143e-10 -0.1 \
 9.767857142857142e-10 -0.1 \
 9.777857142857143e-10 0.03333333333333333 \
 9.857142857142856e-10 0.03333333333333333 \
 9.867142857142857e-10 0.03333333333333333 \
 9.946428571428571e-10 0.03333333333333333 \
 9.956428571428572e-10 -0.1 \
 1.003571428571429e-09 -0.1 \
 1.004571428571429e-09 0.1 \
 1.0125e-09 0.1 \
 1.0135e-09 -0.03333333333333333 \
 1.021428571428571e-09 -0.03333333333333333 \
 1.022428571428572e-09 -0.1 \
 1.030357142857143e-09 -0.1 \
 1.031357142857143e-09 0.03333333333333333 \
 1.039285714285714e-09 0.03333333333333333 \
 1.040285714285714e-09 -0.1 \
 1.048214285714286e-09 -0.1 \
 1.049214285714286e-09 0.1 \
 1.057142857142857e-09 0.1 \
 1.058142857142857e-09 -0.1 \
 1.066071428571428e-09 -0.1 \
 1.067071428571429e-09 0.1 \
 1.075e-09 0.1 \
 1.076e-09 0.1 \
 1.083928571428571e-09 0.1 \
 1.084928571428571e-09 0.1 \
 1.092857142857143e-09 0.1 \
 1.093857142857143e-09 0.03333333333333333 \
 1.101785714285714e-09 0.03333333333333333 \
 1.102785714285714e-09 0.03333333333333333 \
 1.110714285714286e-09 0.03333333333333333 \
 1.111714285714286e-09 -0.03333333333333333 \
 1.119642857142857e-09 -0.03333333333333333 \
 1.120642857142857e-09 -0.1 \
 1.128571428571429e-09 -0.1 \
 1.129571428571429e-09 0.03333333333333333 \
 1.1375e-09 0.03333333333333333 \
 1.1385e-09 0.1 \
 1.146428571428571e-09 0.1 \
 1.147428571428571e-09 -0.03333333333333333 \
 1.155357142857143e-09 -0.03333333333333333 \
 1.156357142857143e-09 0.03333333333333333 \
 1.164285714285714e-09 0.03333333333333333 \
 1.165285714285714e-09 0.03333333333333333 \
 1.173214285714286e-09 0.03333333333333333 \
 1.174214285714286e-09 -0.03333333333333333 \
 1.182142857142857e-09 -0.03333333333333333 \
 1.183142857142857e-09 0.03333333333333333 \
 1.191071428571429e-09 0.03333333333333333 \
 1.192071428571429e-09 0.1 \
 1.2e-09 0.1 \
 1.201e-09 -0.1 \
 1.208928571428571e-09 -0.1 \
 1.209928571428572e-09 -0.03333333333333333 \
 1.217857142857143e-09 -0.03333333333333333 \
 1.218857142857143e-09 0.03333333333333333 \
 1.226785714285714e-09 0.03333333333333333 \
 1.227785714285714e-09 0.1 \
 1.235714285714286e-09 0.1 \
 1.236714285714286e-09 0.03333333333333333 \
 1.244642857142857e-09 0.03333333333333333 \
 1.245642857142857e-09 0.03333333333333333 \
 1.253571428571428e-09 0.03333333333333333 \
 1.254571428571429e-09 0.1 \
 1.2625e-09 0.1 \
 1.2635e-09 0.03333333333333333 \
 1.271428571428571e-09 0.03333333333333333 \
 1.272428571428571e-09 0.1 \
 1.280357142857143e-09 0.1 \
 1.281357142857143e-09 0.1 \
 1.289285714285714e-09 0.1 \
 1.290285714285714e-09 -0.1 \
 1.298214285714286e-09 -0.1 \
 1.299214285714286e-09 0.1 \
 1.307142857142857e-09 0.1 \
 1.308142857142857e-09 -0.03333333333333333 \
 1.316071428571428e-09 -0.03333333333333333 \
 1.317071428571429e-09 0.03333333333333333 \
 1.325e-09 0.03333333333333333 \
 1.326e-09 0.1 \
 1.333928571428571e-09 0.1 \
 1.334928571428571e-09 0.1 \
 1.342857142857143e-09 0.1 \
 1.343857142857143e-09 -0.03333333333333333 \
 1.351785714285714e-09 -0.03333333333333333 \
 1.352785714285714e-09 0.03333333333333333 \
 1.360714285714286e-09 0.03333333333333333 \
 1.361714285714286e-09 -0.03333333333333333 \
 1.369642857142857e-09 -0.03333333333333333 \
 1.370642857142857e-09 -0.03333333333333333 \
 1.378571428571429e-09 -0.03333333333333333 \
 1.379571428571429e-09 0.1 \
 1.3875e-09 0.1 \
 1.3885e-09 0.03333333333333333 \
 1.396428571428571e-09 0.03333333333333333 \
 1.397428571428571e-09 0.03333333333333333 \
 1.405357142857143e-09 0.03333333333333333 \
 1.406357142857143e-09 -0.03333333333333333 \
 1.414285714285714e-09 -0.03333333333333333 \
 1.415285714285714e-09 -0.1 \
 1.423214285714286e-09 -0.1 \
 1.424214285714286e-09 0.1 \
 1.432142857142857e-09 0.1 \
 1.433142857142857e-09 0.1 \
 1.441071428571429e-09 0.1 \
 1.442071428571429e-09 0.1 \
 1.45e-09 0.1 \
 1.451e-09 0.1 \
 1.458928571428571e-09 0.1 \
 1.459928571428572e-09 -0.03333333333333333 \
 1.467857142857143e-09 -0.03333333333333333 \
 1.468857142857143e-09 -0.03333333333333333 \
 1.476785714285714e-09 -0.03333333333333333 \
 1.477785714285714e-09 -0.1 \
 1.485714285714286e-09 -0.1 \
 1.486714285714286e-09 -0.03333333333333333 \
 1.494642857142857e-09 -0.03333333333333333 \
 1.495642857142857e-09 -0.1 \
 1.503571428571428e-09 -0.1 \
 1.504571428571429e-09 -0.1 \
 1.5125e-09 -0.1 \
 1.5135e-09 -0.1 \
 1.521428571428571e-09 -0.1 \
 1.522428571428571e-09 -0.1 \
 1.530357142857143e-09 -0.1 \
 1.531357142857143e-09 -0.03333333333333333 \
 1.539285714285714e-09 -0.03333333333333333 \
 1.540285714285714e-09 0.1 \
 1.548214285714286e-09 0.1 \
 1.549214285714286e-09 0.1 \
 1.557142857142857e-09 0.1 \
 1.558142857142857e-09 0.1 \
 1.566071428571428e-09 0.1 \
 1.567071428571428e-09 -0.1 \
 1.575e-09 -0.1 \
 1.576e-09 -0.03333333333333333 \
 1.583928571428571e-09 -0.03333333333333333 \
 1.584928571428571e-09 0.1 \
 1.592857142857143e-09 0.1 \
 1.593857142857143e-09 -0.03333333333333333 \
 1.601785714285714e-09 -0.03333333333333333 \
 1.602785714285714e-09 0.03333333333333333 \
 1.610714285714286e-09 0.03333333333333333 \
 1.611714285714286e-09 -0.03333333333333333 \
 1.619642857142857e-09 -0.03333333333333333 \
 1.620642857142857e-09 0.1 \
 1.628571428571429e-09 0.1 \
 1.629571428571429e-09 0.1 \
 1.6375e-09 0.1 \
 1.6385e-09 -0.1 \
 1.646428571428571e-09 -0.1 \
 1.647428571428572e-09 0.1 \
 1.655357142857143e-09 0.1 \
 1.656357142857143e-09 0.03333333333333333 \
 1.664285714285714e-09 0.03333333333333333 \
 1.665285714285714e-09 0.03333333333333333 \
 1.673214285714286e-09 0.03333333333333333 \
 1.674214285714286e-09 -0.1 \
 1.682142857142857e-09 -0.1 \
 1.683142857142857e-09 -0.1 \
 1.691071428571428e-09 -0.1 \
 1.692071428571429e-09 0.1 \
 1.7e-09 0.1 \
 1.701e-09 0.03333333333333333 \
 1.708928571428571e-09 0.03333333333333333 \
 1.709928571428571e-09 0.1 \
 1.717857142857143e-09 0.1 \
 1.718857142857143e-09 0.03333333333333333 \
 1.726785714285714e-09 0.03333333333333333 \
 1.727785714285714e-09 -0.03333333333333333 \
 1.735714285714286e-09 -0.03333333333333333 \
 1.736714285714286e-09 0.03333333333333333 \
 1.744642857142857e-09 0.03333333333333333 \
 1.745642857142857e-09 -0.03333333333333333 \
 1.753571428571428e-09 -0.03333333333333333 \
 1.754571428571429e-09 -0.1 \
 1.7625e-09 -0.1 \
 1.7635e-09 -0.1 \
 1.771428571428571e-09 -0.1 \
 1.772428571428571e-09 0.1 \
 1.780357142857143e-09 0.1 \
 1.781357142857143e-09 0.03333333333333333 \
 1.789285714285714e-09 0.03333333333333333 \
 1.790285714285714e-09 -0.03333333333333333 \
 1.798214285714286e-09 -0.03333333333333333 \
 1.799214285714286e-09 0.03333333333333333 \
 1.807142857142857e-09 0.03333333333333333 \
 1.808142857142857e-09 0.03333333333333333 \
 1.816071428571429e-09 0.03333333333333333 \
 1.817071428571429e-09 0.1 \
 1.825e-09 0.1 \
 1.826e-09 0.1 \
 1.833928571428571e-09 0.1 \
 1.834928571428571e-09 0.1 \
 1.842857142857143e-09 0.1 \
 1.843857142857143e-09 0.1 \
 1.851785714285714e-09 0.1 \
 1.852785714285714e-09 0.1 \
 1.860714285714286e-09 0.1 \
 1.861714285714286e-09 -0.1 \
 1.869642857142857e-09 -0.1 \
 1.870642857142857e-09 -0.03333333333333333 \
 1.878571428571428e-09 -0.03333333333333333 \
 1.879571428571428e-09 0.03333333333333333 \
 1.8875e-09 0.03333333333333333 \
 1.8885e-09 -0.1 \
 1.896428571428571e-09 -0.1 \
 1.897428571428571e-09 0.1 \
 1.905357142857143e-09 0.1 \
 1.906357142857143e-09 0.1 \
 1.914285714285714e-09 0.1 \
 1.915285714285714e-09 -0.03333333333333333 \
 1.923214285714286e-09 -0.03333333333333333 \
 1.924214285714286e-09 0.03333333333333333 \
 1.932142857142857e-09 0.03333333333333333 \
 1.933142857142857e-09 -0.1 \
 1.941071428571429e-09 -0.1 \
 1.942071428571429e-09 -0.1 \
 1.95e-09 -0.1 \
 1.951e-09 0.1 \
 1.958928571428572e-09 0.1 \
 1.959928571428571e-09 0.1 \
 1.967857142857143e-09 0.1 \
 1.968857142857143e-09 0.1 \
 1.976785714285714e-09 0.1 \
 1.977785714285714e-09 0.1 \
 1.985714285714286e-09 0.1 \
 1.986714285714286e-09 0.1 \
 1.994642857142857e-09 0.1 \
 1.995642857142857e-09 0.03333333333333333 \
 2.003571428571428e-09 0.03333333333333333 \
 2.004571428571428e-09 -0.03333333333333333 \
 2.0125e-09 -0.03333333333333333 \
 2.0135e-09 -0.1 \
 2.021428571428571e-09 -0.1 \
 2.022428571428571e-09 -0.03333333333333333 \
 2.030357142857143e-09 -0.03333333333333333 \
 2.031357142857143e-09 -0.1 \
 2.039285714285714e-09 -0.1 \
 2.040285714285714e-09 -0.1 \
 2.048214285714286e-09 -0.1 \
 2.049214285714286e-09 -0.1 \
 2.057142857142857e-09 -0.1 \
 2.058142857142857e-09 -0.1 \
 2.066071428571429e-09 -0.1 \
 2.067071428571428e-09 0.1 \
 2.075e-09 0.1 \
 2.076e-09 0.03333333333333333 \
 2.083928571428571e-09 0.03333333333333333 \
 2.084928571428571e-09 0.1 \
 2.092857142857143e-09 0.1 \
 2.093857142857143e-09 -0.1 \
 2.101785714285714e-09 -0.1 \
 2.102785714285714e-09 -0.03333333333333333 \
 2.110714285714286e-09 -0.03333333333333333 \
 2.111714285714286e-09 0.1 \
 2.119642857142857e-09 0.1 \
 2.120642857142857e-09 -0.03333333333333333 \
 2.128571428571429e-09 -0.03333333333333333 \
 2.129571428571429e-09 -0.1 \
 2.1375e-09 -0.1 \
 2.1385e-09 0.03333333333333333 \
 2.146428571428572e-09 0.03333333333333333 \
 2.147428571428571e-09 0.1 \
 2.155357142857143e-09 0.1 \
 2.156357142857143e-09 -0.1 \
 2.164285714285714e-09 -0.1 \
 2.165285714285714e-09 0.03333333333333333 \
 2.173214285714286e-09 0.03333333333333333 \
 2.174214285714286e-09 0.03333333333333333 \
 2.182142857142857e-09 0.03333333333333333 \
 2.183142857142857e-09 0.1 \
 2.191071428571429e-09 0.1 \
 2.192071428571429e-09 -0.1 \
 2.2e-09 -0.1 \
 2.201e-09 0.03333333333333333 \
 2.208928571428572e-09 0.03333333333333333 \
 2.209928571428572e-09 -0.03333333333333333 \
 2.217857142857143e-09 -0.03333333333333333 \
 2.218857142857143e-09 -0.03333333333333333 \
 2.226785714285714e-09 -0.03333333333333333 \
 2.227785714285714e-09 -0.1 \
 2.235714285714286e-09 -0.1 \
 2.236714285714286e-09 0.1 \
 2.244642857142857e-09 0.1 \
 2.245642857142857e-09 -0.1 \
 2.253571428571429e-09 -0.1 \
 2.254571428571428e-09 0.03333333333333333 \
 2.2625e-09 0.03333333333333333 \
 2.2635e-09 -0.03333333333333333 \
 2.271428571428571e-09 -0.03333333333333333 \
 2.272428571428571e-09 0.1 \
 2.280357142857143e-09 0.1 \
 2.281357142857143e-09 0.03333333333333333 \
 2.289285714285714e-09 0.03333333333333333 \
 2.290285714285714e-09 0.1 \
 2.298214285714286e-09 0.1 \
 2.299214285714286e-09 0.03333333333333333 \
 2.307142857142857e-09 0.03333333333333333 \
 2.308142857142857e-09 -0.1 \
 2.316071428571429e-09 -0.1 \
 2.317071428571429e-09 0.03333333333333333 \
 2.325e-09 0.03333333333333333 \
 2.326e-09 0.1 \
 2.333928571428572e-09 0.1 \
 2.334928571428571e-09 0.03333333333333333 \
 2.342857142857143e-09 0.03333333333333333 \
 2.343857142857143e-09 -0.03333333333333333 \
 2.351785714285714e-09 -0.03333333333333333 \
 2.352785714285714e-09 -0.03333333333333333 \
 2.360714285714286e-09 -0.03333333333333333 \
 2.361714285714286e-09 -0.1 \
 2.369642857142857e-09 -0.1 \
 2.370642857142857e-09 -0.1 \
 2.378571428571429e-09 -0.1 \
 2.379571428571429e-09 0.1 \
 2.3875e-09 0.1 \
 2.3885e-09 0.1 \
 2.396428571428572e-09 0.1 \
 2.397428571428572e-09 -0.1 \
 2.405357142857143e-09 -0.1 \
 2.406357142857143e-09 -0.03333333333333333 \
 2.414285714285714e-09 -0.03333333333333333 \
 2.415285714285714e-09 0.03333333333333333 \
 2.423214285714286e-09 0.03333333333333333 \
 2.424214285714286e-09 -0.03333333333333333 \
 2.432142857142857e-09 -0.03333333333333333 \
 2.433142857142857e-09 -0.1 \
 2.441071428571429e-09 -0.1 \
 2.442071428571428e-09 0.03333333333333333 \
 2.45e-09 0.03333333333333333 \
 2.451e-09 0.03333333333333333 \
 2.458928571428571e-09 0.03333333333333333 \
 2.459928571428571e-09 -0.03333333333333333 \
 2.467857142857143e-09 -0.03333333333333333 \
 2.468857142857143e-09 -0.1 \
 2.476785714285714e-09 -0.1 \
 2.477785714285714e-09 0.03333333333333333 \
 2.485714285714286e-09 0.03333333333333333 \
 2.486714285714286e-09 0.1 \
 2.494642857142857e-09 0.1 \
 2.495642857142857e-09 0.1 \
 2.503571428571429e-09 0.1 \
 2.504571428571429e-09 -0.03333333333333333 \
 2.5125e-09 -0.03333333333333333 \
 2.5135e-09 0.1 \
 2.521428571428572e-09 0.1 \
 2.522428571428572e-09 0.1 \
 2.530357142857143e-09 0.1 \
 2.531357142857143e-09 -0.1 \
 2.539285714285715e-09 -0.1 \
 2.540285714285714e-09 -0.03333333333333333 \
 2.548214285714286e-09 -0.03333333333333333 \
 2.549214285714286e-09 0.1 \
 2.557142857142857e-09 0.1 \
 2.558142857142857e-09 -0.1 \
 2.566071428571429e-09 -0.1 \
 2.567071428571429e-09 0.1 \
 2.575e-09 0.1 \
 2.576e-09 -0.1 \
 2.583928571428571e-09 -0.1 \
 2.584928571428571e-09 0.1 \
 2.592857142857143e-09 0.1 \
 2.593857142857143e-09 -0.1 \
 2.601785714285714e-09 -0.1 \
 2.602785714285714e-09 -0.03333333333333333 \
 2.610714285714286e-09 -0.03333333333333333 \
 2.611714285714286e-09 -0.1 \
 2.619642857142857e-09 -0.1 \
 2.620642857142857e-09 0.1 \
 2.628571428571429e-09 0.1 \
 2.629571428571428e-09 0.1 \
 2.6375e-09 0.1 \
 2.6385e-09 -0.03333333333333333 \
 2.646428571428571e-09 -0.03333333333333333 \
 2.647428571428571e-09 -0.1 \
 2.655357142857143e-09 -0.1 \
 2.656357142857143e-09 0.03333333333333333 \
 2.664285714285714e-09 0.03333333333333333 \
 2.665285714285714e-09 -0.1 \
 2.673214285714286e-09 -0.1 \
 2.674214285714286e-09 -0.1 \
 2.682142857142857e-09 -0.1 \
 2.683142857142857e-09 -0.03333333333333333 \
 2.691071428571429e-09 -0.03333333333333333 \
 2.692071428571429e-09 0.03333333333333333 \
 2.7e-09 0.03333333333333333 \
 2.701e-09 0.03333333333333333 \
 2.708928571428572e-09 0.03333333333333333 \
 2.709928571428572e-09 0.1 \
 2.717857142857143e-09 0.1 \
 2.718857142857143e-09 -0.03333333333333333 \
 2.726785714285715e-09 -0.03333333333333333 \
 2.727785714285714e-09 0.1 \
 2.735714285714286e-09 0.1 \
 2.736714285714286e-09 -0.1 \
 2.744642857142857e-09 -0.1 \
 2.745642857142857e-09 -0.1 \
 2.753571428571428e-09 -0.1 \
 2.754571428571428e-09 0.1 \
 2.7625e-09 0.1 \
 2.7635e-09 -0.03333333333333333 \
 2.771428571428571e-09 -0.03333333333333333 \
 2.772428571428571e-09 -0.1 \
 2.780357142857143e-09 -0.1 \
 2.781357142857143e-09 0.03333333333333333 \
 2.789285714285714e-09 0.03333333333333333 \
 2.790285714285714e-09 -0.03333333333333333 \
 2.798214285714286e-09 -0.03333333333333333 \
 2.799214285714286e-09 0.03333333333333333 \
 2.807142857142857e-09 0.03333333333333333 \
 2.808142857142857e-09 -0.03333333333333333 \
 2.816071428571429e-09 -0.03333333333333333 \
 2.817071428571429e-09 0.03333333333333333 \
 2.825e-09 0.03333333333333333 \
 2.826e-09 -0.03333333333333333 \
 2.833928571428572e-09 -0.03333333333333333 \
 2.834928571428571e-09 -0.03333333333333333 \
 2.842857142857143e-09 -0.03333333333333333 \
 2.843857142857143e-09 -0.03333333333333333 \
 2.851785714285714e-09 -0.03333333333333333 \
 2.852785714285714e-09 0.1 \
 2.860714285714286e-09 0.1 \
 2.861714285714286e-09 -0.1 \
 2.869642857142857e-09 -0.1 \
 2.870642857142857e-09 -0.1 \
 2.878571428571429e-09 -0.1 \
 2.879571428571429e-09 -0.1 \
 2.8875e-09 -0.1 \
 2.8885e-09 -0.1 \
 2.896428571428572e-09 -0.1 \
 2.897428571428572e-09 -0.1 \
 2.905357142857143e-09 -0.1 \
 2.906357142857143e-09 -0.03333333333333333 \
 2.914285714285715e-09 -0.03333333333333333 \
 2.915285714285714e-09 -0.03333333333333333 \
 2.923214285714286e-09 -0.03333333333333333 \
 2.924214285714286e-09 -0.03333333333333333 \
 2.932142857142857e-09 -0.03333333333333333 \
 2.933142857142857e-09 0.1 \
 2.941071428571428e-09 0.1 \
 2.942071428571428e-09 0.03333333333333333 \
 2.95e-09 0.03333333333333333 \
 2.951e-09 0.03333333333333333 \
 2.958928571428571e-09 0.03333333333333333 \
 2.959928571428571e-09 0.1 \
 2.967857142857143e-09 0.1 \
 2.968857142857143e-09 -0.1 \
 2.976785714285714e-09 -0.1 \
 2.977785714285714e-09 0.03333333333333333 \
 2.985714285714286e-09 0.03333333333333333 \
 2.986714285714286e-09 0.03333333333333333 \
 2.994642857142857e-09 0.03333333333333333 \
 2.995642857142857e-09 -0.03333333333333333 \
 3.003571428571429e-09 -0.03333333333333333 \
 3.004571428571429e-09 0.1 \
 3.0125e-09 0.1 \
 3.0135e-09 0.03333333333333333 \
 3.021428571428572e-09 0.03333333333333333 \
 3.022428571428571e-09 -0.1 \
 3.030357142857143e-09 -0.1 \
 3.031357142857143e-09 -0.03333333333333333 \
 3.039285714285714e-09 -0.03333333333333333 \
 3.040285714285714e-09 -0.03333333333333333 \
 3.048214285714286e-09 -0.03333333333333333 \
 3.049214285714286e-09 -0.03333333333333333 \
 3.057142857142857e-09 -0.03333333333333333 \
 3.058142857142857e-09 -0.1 \
 3.066071428571429e-09 -0.1 \
 3.067071428571429e-09 -0.03333333333333333 \
 3.075e-09 -0.03333333333333333 \
 3.076e-09 -0.03333333333333333 \
 3.083928571428572e-09 -0.03333333333333333 \
 3.084928571428572e-09 0.03333333333333333 \
 3.092857142857143e-09 0.03333333333333333 \
 3.093857142857143e-09 -0.1 \
 3.101785714285714e-09 -0.1 \
 3.102785714285714e-09 -0.03333333333333333 \
 3.110714285714286e-09 -0.03333333333333333 \
 3.111714285714286e-09 -0.03333333333333333 \
 3.119642857142857e-09 -0.03333333333333333 \
 3.120642857142857e-09 -0.03333333333333333 \
 3.128571428571429e-09 -0.03333333333333333 \
 3.129571428571428e-09 0.03333333333333333 \
 3.1375e-09 0.03333333333333333 \
 3.1385e-09 0.03333333333333333 \
 3.146428571428571e-09 0.03333333333333333 \
 3.147428571428571e-09 -0.03333333333333333 \
 3.155357142857143e-09 -0.03333333333333333 \
 3.156357142857143e-09 0.1 \
 3.164285714285714e-09 0.1 \
 3.165285714285714e-09 0.03333333333333333 \
 3.173214285714286e-09 0.03333333333333333 \
 3.174214285714286e-09 0.1 \
 3.182142857142857e-09 0.1 \
 3.183142857142857e-09 -0.1 \
 3.191071428571429e-09 -0.1 \
 3.192071428571429e-09 0.1 \
 3.2e-09 0.1 \
 3.201e-09 -0.03333333333333333 \
 3.208928571428572e-09 -0.03333333333333333 \
 3.209928571428571e-09 0.03333333333333333 \
 3.217857142857143e-09 0.03333333333333333 \
 3.218857142857143e-09 0.1 \
 3.226785714285714e-09 0.1 \
 3.227785714285714e-09 0.03333333333333333 \
 3.235714285714286e-09 0.03333333333333333 \
 3.236714285714286e-09 -0.03333333333333333 \
 3.244642857142857e-09 -0.03333333333333333 \
 3.245642857142857e-09 0.03333333333333333 \
 3.253571428571429e-09 0.03333333333333333 \
 3.254571428571429e-09 -0.03333333333333333 \
 3.2625e-09 -0.03333333333333333 \
 3.2635e-09 0.03333333333333333 \
 3.271428571428572e-09 0.03333333333333333 \
 3.272428571428572e-09 -0.1 \
 3.280357142857143e-09 -0.1 \
 3.281357142857143e-09 -0.1 \
 3.289285714285714e-09 -0.1 \
 3.290285714285714e-09 -0.1 \
 3.298214285714286e-09 -0.1 \
 3.299214285714286e-09 -0.1 \
 3.307142857142857e-09 -0.1 \
 3.308142857142857e-09 0.1 \
 3.316071428571429e-09 0.1 \
 3.317071428571428e-09 -0.03333333333333333 \
 3.325e-09 -0.03333333333333333 \
 3.326e-09 -0.03333333333333333 \
 3.333928571428571e-09 -0.03333333333333333 \
 3.334928571428571e-09 -0.1 \
 3.342857142857143e-09 -0.1 \
 3.343857142857143e-09 -0.03333333333333333 \
 3.351785714285714e-09 -0.03333333333333333 \
 3.352785714285714e-09 0.03333333333333333 \
 3.360714285714286e-09 0.03333333333333333 \
 3.361714285714286e-09 0.1 \
 3.369642857142857e-09 0.1 \
 3.370642857142857e-09 -0.03333333333333333 \
 3.378571428571429e-09 -0.03333333333333333 \
 3.379571428571429e-09 -0.03333333333333333 \
 3.3875e-09 -0.03333333333333333 \
 3.3885e-09 0.1 \
 3.396428571428572e-09 0.1 \
 3.397428571428571e-09 -0.03333333333333333 \
 3.405357142857143e-09 -0.03333333333333333 \
 3.406357142857143e-09 -0.1 \
 3.414285714285714e-09 -0.1 \
 3.415285714285714e-09 0.1 \
 3.423214285714286e-09 0.1 \
 3.424214285714286e-09 -0.03333333333333333 \
 3.432142857142857e-09 -0.03333333333333333 \
 3.433142857142857e-09 -0.1 \
 3.441071428571429e-09 -0.1 \
 3.442071428571429e-09 -0.03333333333333333 \
 3.45e-09 -0.03333333333333333 \
 3.451e-09 0.1 \
 3.458928571428571e-09 0.1 \
 3.459928571428571e-09 0.03333333333333333 \
 3.467857142857143e-09 0.03333333333333333 \
 3.468857142857143e-09 0.03333333333333333 \
 3.476785714285714e-09 0.03333333333333333 \
 3.477785714285714e-09 -0.1 \
 3.485714285714286e-09 -0.1 \
 3.486714285714286e-09 -0.03333333333333333 \
 3.494642857142857e-09 -0.03333333333333333 \
 3.495642857142857e-09 0.1 \
 3.503571428571429e-09 0.1 \
 3.504571428571428e-09 0.1 \
 3.5125e-09 0.1 \
 3.5135e-09 0.03333333333333333 \
 3.521428571428571e-09 0.03333333333333333 \
 3.522428571428571e-09 -0.1 \
 3.530357142857143e-09 -0.1 \
 3.531357142857143e-09 0.1 \
 3.539285714285714e-09 0.1 \
 3.540285714285714e-09 -0.03333333333333333 \
 3.548214285714286e-09 -0.03333333333333333 \
 3.549214285714286e-09 0.1 \
 3.557142857142857e-09 0.1 \
 3.558142857142857e-09 -0.03333333333333333 \
 3.566071428571429e-09 -0.03333333333333333 \
 3.567071428571429e-09 0.1 \
 3.575e-09 0.1 \
 3.576e-09 -0.1 \
 3.583928571428572e-09 -0.1 \
 3.584928571428572e-09 -0.03333333333333333 \
 3.592857142857143e-09 -0.03333333333333333 \
 3.593857142857143e-09 0.1 \
 3.601785714285715e-09 0.1 \
 3.602785714285714e-09 -0.1 \
 3.610714285714286e-09 -0.1 \
 3.611714285714286e-09 -0.03333333333333333 \
 3.619642857142857e-09 -0.03333333333333333 \
 3.620642857142857e-09 0.1 \
 3.628571428571428e-09 0.1 \
 3.629571428571428e-09 -0.1 \
 3.6375e-09 -0.1 \
 3.6385e-09 -0.1 \
 3.646428571428571e-09 -0.1 \
 3.647428571428571e-09 0.1 \
 3.655357142857143e-09 0.1 \
 3.656357142857143e-09 0.03333333333333333 \
 3.664285714285714e-09 0.03333333333333333 \
 3.665285714285714e-09 0.1 \
 3.673214285714286e-09 0.1 \
 3.674214285714286e-09 0.03333333333333333 \
 3.682142857142857e-09 0.03333333333333333 \
 3.683142857142857e-09 0.03333333333333333 \
 3.691071428571429e-09 0.03333333333333333 \
 3.692071428571428e-09 0.1 \
 3.7e-09 0.1 \
 3.701e-09 0.03333333333333333 \
 3.708928571428571e-09 0.03333333333333333 \
 3.709928571428571e-09 0.03333333333333333 \
 3.717857142857143e-09 0.03333333333333333 \
 3.718857142857143e-09 -0.1 \
 3.726785714285714e-09 -0.1 \
 3.727785714285714e-09 -0.1 \
 3.735714285714286e-09 -0.1 \
 3.736714285714286e-09 -0.1 \
 3.744642857142857e-09 -0.1 \
 3.745642857142857e-09 -0.03333333333333333 \
 3.753571428571429e-09 -0.03333333333333333 \
 3.754571428571429e-09 0.03333333333333333 \
 3.7625e-09 0.03333333333333333 \
 3.7635e-09 0.1 \
 3.771428571428572e-09 0.1 \
 3.772428571428572e-09 0.03333333333333333 \
 3.780357142857143e-09 0.03333333333333333 \
 3.781357142857143e-09 -0.1 \
 3.789285714285715e-09 -0.1 \
 3.790285714285715e-09 -0.03333333333333333 \
 3.798214285714286e-09 -0.03333333333333333 \
 3.799214285714286e-09 0.1 \
 3.807142857142857e-09 0.1 \
 3.808142857142857e-09 -0.03333333333333333 \
 3.816071428571428e-09 -0.03333333333333333 \
 3.817071428571429e-09 0.1 \
 3.825e-09 0.1 \
 3.826e-09 -0.03333333333333333 \
 3.833928571428571e-09 -0.03333333333333333 \
 3.834928571428572e-09 -0.1 \
 3.842857142857142e-09 -0.1 \
 3.843857142857143e-09 -0.1 \
 3.851785714285714e-09 -0.1 \
 3.852785714285715e-09 -0.03333333333333333 \
 3.860714285714285e-09 -0.03333333333333333 \
 3.861714285714286e-09 -0.1 \
 3.869642857142857e-09 -0.1 \
 3.870642857142857e-09 -0.1 \
 3.878571428571428e-09 -0.1 \
 3.879571428571429e-09 0.03333333333333333 \
 3.8875e-09 0.03333333333333333 \
 3.8885e-09 0.1 \
 3.896428571428571e-09 0.1 \
 3.897428571428571e-09 0.1 \
 3.905357142857143e-09 0.1 \
 3.906357142857143e-09 0.03333333333333333 \
 3.914285714285714e-09 0.03333333333333333 \
 3.915285714285714e-09 -0.03333333333333333 \
 3.923214285714286e-09 -0.03333333333333333 \
 3.924214285714286e-09 0.03333333333333333 \
 3.932142857142857e-09 0.03333333333333333 \
 3.933142857142857e-09 0.03333333333333333 \
 3.941071428571429e-09 0.03333333333333333 \
 3.942071428571429e-09 -0.1 \
 3.95e-09 -0.1 \
 3.951e-09 -0.1 \
 3.958928571428572e-09 -0.1 \
 3.959928571428572e-09 -0.03333333333333333 \
 3.967857142857143e-09 -0.03333333333333333 \
 3.968857142857143e-09 0.03333333333333333 \
 3.976785714285715e-09 0.03333333333333333 \
 3.977785714285715e-09 0.03333333333333333 \
 3.985714285714286e-09 0.03333333333333333 \
 3.986714285714286e-09 0.1 \
 3.994642857142857e-09 0.1 \
 3.995642857142858e-09 -0.03333333333333333 \
 4.003571428571428e-09 -0.03333333333333333 \
 4.004571428571429e-09 -0.03333333333333333 \
 4.0125e-09 -0.03333333333333333 \
 4.013500000000001e-09 0.03333333333333333 \
 4.021428571428571e-09 0.03333333333333333 \
 4.022428571428572e-09 -0.03333333333333333 \
 4.030357142857143e-09 -0.03333333333333333 \
 4.031357142857144e-09 -0.1 \
 4.039285714285714e-09 -0.1 \
 4.040285714285715e-09 0.03333333333333333 \
 4.048214285714286e-09 0.03333333333333333 \
 4.049214285714286e-09 0.1 \
 4.057142857142857e-09 0.1 \
 4.058142857142858e-09 -0.1 \
 4.066071428571429e-09 -0.1 \
 4.067071428571429e-09 -0.1 \
 4.075e-09 -0.1 \
 4.076e-09 0.1 \
 4.083928571428571e-09 0.1 \
 4.084928571428571e-09 -0.03333333333333333 \
 4.092857142857143e-09 -0.03333333333333333 \
 4.093857142857143e-09 -0.03333333333333333 \
 4.101785714285714e-09 -0.03333333333333333 \
 4.102785714285714e-09 -0.1 \
 4.110714285714286e-09 -0.1 \
 4.111714285714286e-09 0.1 \
 4.119642857142857e-09 0.1 \
 4.120642857142857e-09 0.03333333333333333 \
 4.128571428571429e-09 0.03333333333333333 \
 4.129571428571429e-09 -0.1 \
 4.1375e-09 -0.1 \
 4.1385e-09 -0.1 \
 4.146428571428572e-09 -0.1 \
 4.147428571428572e-09 -0.03333333333333333 \
 4.155357142857143e-09 -0.03333333333333333 \
 4.156357142857143e-09 -0.03333333333333333 \
 4.164285714285715e-09 -0.03333333333333333 \
 4.165285714285715e-09 0.03333333333333333 \
 4.173214285714286e-09 0.03333333333333333 \
 4.174214285714286e-09 0.03333333333333333 \
 4.182142857142857e-09 0.03333333333333333 \
 4.183142857142858e-09 0.1 \
 4.191071428571429e-09 0.1 \
 4.192071428571429e-09 -0.1 \
 4.2e-09 -0.1 \
 4.201000000000001e-09 -0.03333333333333333 \
 4.208928571428571e-09 -0.03333333333333333 \
 4.209928571428572e-09 0.1 \
 4.217857142857143e-09 0.1 \
 4.218857142857144e-09 0.1 \
 4.226785714285714e-09 0.1 \
 4.227785714285715e-09 0.1 \
 4.235714285714286e-09 0.1 \
 4.236714285714286e-09 -0.1 \
 4.244642857142857e-09 -0.1 \
 4.245642857142858e-09 0.1 \
 4.253571428571428e-09 0.1 \
 4.254571428571429e-09 -0.03333333333333333 \
 4.2625e-09 -0.03333333333333333 \
 4.2635e-09 -0.03333333333333333 \
 4.271428571428571e-09 -0.03333333333333333 \
 4.272428571428571e-09 -0.1 \
 4.280357142857143e-09 -0.1 \
 4.281357142857143e-09 0.03333333333333333 \
 4.289285714285714e-09 0.03333333333333333 \
 4.290285714285714e-09 0.03333333333333333 \
 4.298214285714286e-09 0.03333333333333333 \
 4.299214285714286e-09 -0.1 \
 4.307142857142857e-09 -0.1 \
 4.308142857142857e-09 0.03333333333333333 \
 4.316071428571429e-09 0.03333333333333333 \
 4.317071428571429e-09 0.1 \
 4.325e-09 0.1 \
 4.326e-09 -0.03333333333333333 \
 4.333928571428572e-09 -0.03333333333333333 \
 4.334928571428572e-09 0.1 \
 4.342857142857143e-09 0.1 \
 4.343857142857143e-09 -0.03333333333333333 \
 4.351785714285715e-09 -0.03333333333333333 \
 4.352785714285715e-09 -0.03333333333333333 \
 4.360714285714286e-09 -0.03333333333333333 \
 4.361714285714286e-09 -0.1 \
 4.369642857142858e-09 -0.1 \
 4.370642857142858e-09 0.03333333333333333 \
 4.378571428571429e-09 0.03333333333333333 \
 4.379571428571429e-09 -0.1 \
 4.3875e-09 -0.1 \
 4.388500000000001e-09 0.03333333333333333 \
 4.396428571428571e-09 0.03333333333333333 \
 4.397428571428572e-09 0.1 \
 4.405357142857143e-09 0.1 \
 4.406357142857144e-09 0.03333333333333333 \
 4.414285714285714e-09 0.03333333333333333 \
 4.415285714285715e-09 -0.1 \
 4.423214285714285e-09 -0.1 \
 4.424214285714286e-09 -0.1 \
 4.432142857142857e-09 -0.1 \
 4.433142857142858e-09 0.1 \
 4.441071428571428e-09 0.1 \
 4.442071428571429e-09 -0.03333333333333333 \
 4.45e-09 -0.03333333333333333 \
 4.451e-09 0.03333333333333333 \
 4.458928571428571e-09 0.03333333333333333 \
 4.459928571428571e-09 0.03333333333333333 \
 4.467857142857143e-09 0.03333333333333333 \
 4.468857142857143e-09 0.1 \
 4.476785714285714e-09 0.1 \
 4.477785714285714e-09 0.1 \
 4.485714285714286e-09 0.1 \
 4.486714285714286e-09 0.1 \
 4.494642857142857e-09 0.1 \
 4.495642857142857e-09 0.1 \
 4.503571428571429e-09 0.1 \
 4.504571428571429e-09 0.1 \
 4.5125e-09 0.1 \
 4.5135e-09 -0.1 \
 4.521428571428572e-09 -0.1 \
 4.522428571428572e-09 -0.03333333333333333 \
 4.530357142857143e-09 -0.03333333333333333 \
 4.531357142857143e-09 -0.03333333333333333 \
 4.539285714285715e-09 -0.03333333333333333 \
 4.540285714285715e-09 -0.1 \
 4.548214285714286e-09 -0.1 \
 4.549214285714286e-09 0.1 \
 4.557142857142858e-09 0.1 \
 4.558142857142858e-09 -0.03333333333333333 \
 4.566071428571429e-09 -0.03333333333333333 \
 4.567071428571429e-09 -0.1 \
 4.575e-09 -0.1 \
 4.576000000000001e-09 -0.03333333333333333 \
 4.583928571428571e-09 -0.03333333333333333 \
 4.584928571428572e-09 0.1 \
 4.592857142857143e-09 0.1 \
 4.593857142857144e-09 -0.1 \
 4.601785714285714e-09 -0.1 \
 4.602785714285715e-09 -0.03333333333333333 \
 4.610714285714285e-09 -0.03333333333333333 \
 4.611714285714286e-09 -0.03333333333333333 \
 4.619642857142857e-09 -0.03333333333333333 \
 4.620642857142858e-09 0.1 \
 4.628571428571428e-09 0.1 \
 4.629571428571429e-09 -0.1 \
 4.6375e-09 -0.1 \
 4.6385e-09 -0.1 \
 4.646428571428571e-09 -0.1 \
 4.647428571428572e-09 -0.1 \
 4.655357142857143e-09 -0.1 \
 4.656357142857143e-09 0.03333333333333333 \
 4.664285714285714e-09 0.03333333333333333 \
 4.665285714285714e-09 -0.1 \
 4.673214285714286e-09 -0.1 \
 4.674214285714286e-09 -0.1 \
 4.682142857142857e-09 -0.1 \
 4.683142857142857e-09 0.03333333333333333 \
 4.691071428571429e-09 0.03333333333333333 \
 4.692071428571429e-09 0.1 \
 4.7e-09 0.1 \
 4.701e-09 0.03333333333333333 \
 4.708928571428572e-09 0.03333333333333333 \
 4.709928571428572e-09 -0.03333333333333333 \
 4.717857142857143e-09 -0.03333333333333333 \
 4.718857142857143e-09 -0.1 \
 4.726785714285715e-09 -0.1 \
 4.727785714285715e-09 0.1 \
 4.735714285714286e-09 0.1 \
 4.736714285714286e-09 0.1 \
 4.744642857142858e-09 0.1 \
 4.745642857142858e-09 -0.1 \
 4.753571428571429e-09 -0.1 \
 4.754571428571429e-09 -0.1 \
 4.7625e-09 -0.1 \
 4.763500000000001e-09 -0.03333333333333333 \
 4.771428571428571e-09 -0.03333333333333333 \
 4.772428571428572e-09 -0.03333333333333333 \
 4.780357142857143e-09 -0.03333333333333333 \
 4.781357142857143e-09 0.03333333333333333 \
 4.789285714285714e-09 0.03333333333333333 \
 4.790285714285715e-09 -0.1 \
 4.798214285714285e-09 -0.1 \
 4.799214285714286e-09 -0.1 \
 4.807142857142857e-09 -0.1 \
 4.808142857142858e-09 0.1 \
 4.816071428571428e-09 0.1 \
 4.817071428571429e-09 0.03333333333333333 \
 4.825e-09 0.03333333333333333 \
 4.826e-09 -0.1 \
 4.833928571428571e-09 -0.1 \
 4.834928571428572e-09 0.1 \
 4.842857142857143e-09 0.1 \
 4.843857142857143e-09 -0.03333333333333333 \
 4.851785714285714e-09 -0.03333333333333333 \
 4.852785714285714e-09 -0.1 \
 4.860714285714286e-09 -0.1 \
 4.861714285714286e-09 0.1 \
 4.869642857142857e-09 0.1 \
 4.870642857142857e-09 -0.03333333333333333 \
 4.878571428571429e-09 -0.03333333333333333 \
 4.879571428571429e-09 0.03333333333333333 \
 4.8875e-09 0.03333333333333333 \
 4.8885e-09 -0.03333333333333333 \
 4.896428571428572e-09 -0.03333333333333333 \
 4.897428571428572e-09 0.03333333333333333 \
 4.905357142857143e-09 0.03333333333333333 \
 4.906357142857143e-09 0.03333333333333333 \
 4.914285714285715e-09 0.03333333333333333 \
 4.915285714285715e-09 -0.1 \
 4.923214285714286e-09 -0.1 \
 4.924214285714286e-09 0.03333333333333333 \
 4.932142857142858e-09 0.03333333333333333 \
 4.933142857142858e-09 0.03333333333333333 \
 4.941071428571429e-09 0.03333333333333333 \
 4.942071428571429e-09 -0.1 \
 4.95e-09 -0.1 \
 4.951e-09 -0.1 \
 4.958928571428572e-09 -0.1 \
 4.959928571428572e-09 0.03333333333333333 \
 4.967857142857143e-09 0.03333333333333333 \
 4.968857142857143e-09 -0.03333333333333333 \
 4.976785714285714e-09 -0.03333333333333333 \
 4.977785714285715e-09 -0.03333333333333333 \
 4.985714285714285e-09 -0.03333333333333333 \
 4.986714285714286e-09 0.03333333333333333 \
 4.994642857142857e-09 0.03333333333333333 \
 4.995642857142858e-09 0.1 \
 5.003571428571428e-09 0.1 \
 5.004571428571429e-09 -0.03333333333333333 \
 5.0125e-09 -0.03333333333333333 \
 5.013500000000001e-09 -0.1 \
 5.021428571428571e-09 -0.1 \
 5.022428571428572e-09 0.1 \
 5.030357142857143e-09 0.1 \
 5.031357142857143e-09 0.03333333333333333 \
 5.039285714285714e-09 0.03333333333333333 \
 5.040285714285714e-09 -0.03333333333333333 \
 5.048214285714286e-09 -0.03333333333333333 \
 5.049214285714286e-09 0.1 \
 5.057142857142857e-09 0.1 \
 5.058142857142857e-09 0.1 \
 5.066071428571429e-09 0.1 \
 5.067071428571429e-09 0.03333333333333333 \
 5.075e-09 0.03333333333333333 \
 5.076e-09 0.1 \
 5.083928571428572e-09 0.1 \
 5.084928571428572e-09 -0.1 \
 5.092857142857143e-09 -0.1 \
 5.093857142857143e-09 0.03333333333333333 \
 5.101785714285715e-09 0.03333333333333333 \
 5.102785714285715e-09 0.03333333333333333 \
 5.110714285714286e-09 0.03333333333333333 \
 5.111714285714286e-09 0.1 \
 5.119642857142858e-09 0.1 \
 5.120642857142858e-09 0.03333333333333333 \
 5.128571428571429e-09 0.03333333333333333 \
 5.129571428571429e-09 0.03333333333333333 \
 5.1375e-09 0.03333333333333333 \
 5.1385e-09 0.03333333333333333 \
 5.146428571428572e-09 0.03333333333333333 \
 5.147428571428572e-09 0.03333333333333333 \
 5.155357142857143e-09 0.03333333333333333 \
 5.156357142857143e-09 0.03333333333333333 \
 5.164285714285714e-09 0.03333333333333333 \
 5.165285714285715e-09 -0.03333333333333333 \
 5.173214285714285e-09 -0.03333333333333333 \
 5.174214285714286e-09 -0.03333333333333333 \
 5.182142857142857e-09 -0.03333333333333333 \
 5.183142857142858e-09 -0.03333333333333333 \
 5.191071428571428e-09 -0.03333333333333333 \
 5.192071428571429e-09 -0.03333333333333333 \
 5.2e-09 -0.03333333333333333 \
 5.201000000000001e-09 -0.1 \
 5.208928571428571e-09 -0.1 \
 5.209928571428572e-09 0.1 \
 5.217857142857143e-09 0.1 \
 5.218857142857143e-09 0.03333333333333333 \
 5.226785714285714e-09 0.03333333333333333 \
 5.227785714285714e-09 -0.1 \
 5.235714285714286e-09 -0.1 \
 5.236714285714286e-09 -0.1 \
 5.244642857142857e-09 -0.1 \
 5.245642857142857e-09 0.03333333333333333 \
 5.253571428571429e-09 0.03333333333333333 \
 5.254571428571429e-09 -0.1 \
 5.2625e-09 -0.1 \
 5.2635e-09 0.03333333333333333 \
 5.271428571428572e-09 0.03333333333333333 \
 5.272428571428572e-09 -0.1 \
 5.280357142857143e-09 -0.1 \
 5.281357142857143e-09 0.1 \
 5.289285714285715e-09 0.1 \
 5.290285714285715e-09 -0.03333333333333333 \
 5.298214285714286e-09 -0.03333333333333333 \
 5.299214285714286e-09 0.1 \
 5.307142857142857e-09 0.1 \
 5.308142857142857e-09 0.03333333333333333 \
 5.316071428571429e-09 0.03333333333333333 \
 5.317071428571429e-09 -0.03333333333333333 \
 5.325e-09 -0.03333333333333333 \
 5.326e-09 -0.03333333333333333 \
 5.333928571428572e-09 -0.03333333333333333 \
 5.334928571428572e-09 -0.1 \
 5.342857142857143e-09 -0.1 \
 5.343857142857143e-09 -0.03333333333333333 \
 5.351785714285714e-09 -0.03333333333333333 \
 5.352785714285715e-09 0.03333333333333333 \
 5.360714285714286e-09 0.03333333333333333 \
 5.361714285714286e-09 0.1 \
 5.369642857142857e-09 0.1 \
 5.370642857142858e-09 0.1 \
 5.378571428571428e-09 0.1 \
 5.379571428571429e-09 -0.03333333333333333 \
 5.3875e-09 -0.03333333333333333 \
 5.388500000000001e-09 -0.1 \
 5.396428571428571e-09 -0.1 \
 5.397428571428572e-09 0.1 \
 5.405357142857143e-09 0.1 \
 5.406357142857143e-09 0.03333333333333333 \
 5.414285714285714e-09 0.03333333333333333 \
 5.415285714285715e-09 0.03333333333333333 \
 5.423214285714286e-09 0.03333333333333333 \
 5.424214285714286e-09 -0.1 \
 5.432142857142857e-09 -0.1 \
 5.433142857142857e-09 0.1 \
 5.441071428571429e-09 0.1 \
 5.442071428571429e-09 -0.1 \
 5.45e-09 -0.1 \
 5.451e-09 0.03333333333333333 \
 5.458928571428572e-09 0.03333333333333333 \
 5.459928571428572e-09 -0.1 \
 5.467857142857143e-09 -0.1 \
 5.468857142857143e-09 -0.1 \
 5.476785714285714e-09 -0.1 \
 5.477785714285714e-09 -0.03333333333333333 \
 5.485714285714286e-09 -0.03333333333333333 \
 5.486714285714286e-09 0.1 \
 5.494642857142857e-09 0.1 \
 5.495642857142857e-09 -0.1 \
 5.503571428571429e-09 -0.1 \
 5.504571428571429e-09 -0.1 \
 5.5125e-09 -0.1 \
 5.5135e-09 -0.03333333333333333 \
 5.521428571428572e-09 -0.03333333333333333 \
 5.522428571428572e-09 0.03333333333333333 \
 5.530357142857143e-09 0.03333333333333333 \
 5.531357142857143e-09 0.1 \
 5.539285714285714e-09 0.1 \
 5.540285714285715e-09 0.03333333333333333 \
 5.548214285714286e-09 0.03333333333333333 \
 5.549214285714286e-09 0.03333333333333333 \
 5.557142857142857e-09 0.03333333333333333 \
 5.558142857142858e-09 -0.1 \
 5.566071428571428e-09 -0.1 \
 5.567071428571429e-09 0.03333333333333333 \
 5.575e-09 0.03333333333333333 \
 5.576000000000001e-09 -0.1 \
 5.583928571428571e-09 -0.1 \
 5.584928571428572e-09 -0.1 \
 5.592857142857143e-09 -0.1 \
 5.593857142857143e-09 0.03333333333333333 \
 5.601785714285714e-09 0.03333333333333333 \
 5.602785714285715e-09 -0.1 \
 5.610714285714286e-09 -0.1 \
 5.611714285714286e-09 -0.1 \
 5.619642857142857e-09 -0.1 \
 5.620642857142857e-09 -0.1 \
 5.628571428571429e-09 -0.1 \
 5.629571428571429e-09 0.1 \
 5.6375e-09 0.1 \
 5.6385e-09 -0.03333333333333333 \
 5.646428571428572e-09 -0.03333333333333333 \
 5.647428571428572e-09 0.03333333333333333 \
 5.655357142857143e-09 0.03333333333333333 \
 5.656357142857143e-09 -0.1 \
 5.664285714285714e-09 -0.1 \
 5.665285714285714e-09 0.03333333333333333 \
 5.673214285714286e-09 0.03333333333333333 \
 5.674214285714286e-09 0.03333333333333333 \
 5.682142857142857e-09 0.03333333333333333 \
 5.683142857142857e-09 0.03333333333333333 \
 5.691071428571429e-09 0.03333333333333333 \
 5.692071428571429e-09 0.1 \
 5.7e-09 0.1 \
 5.701e-09 0.1 \
 5.708928571428572e-09 0.1 \
 5.709928571428572e-09 -0.1 \
 5.717857142857143e-09 -0.1 \
 5.718857142857143e-09 -0.1 \
 5.726785714285715e-09 -0.1 \
 5.727785714285715e-09 -0.1 \
 5.735714285714286e-09 -0.1 \
 5.736714285714286e-09 0.1 \
 5.744642857142857e-09 0.1 \
 5.745642857142858e-09 -0.1 \
 5.753571428571428e-09 -0.1 \
 5.754571428571429e-09 0.1 \
 5.7625e-09 0.1 \
 5.763500000000001e-09 0.03333333333333333 \
 5.771428571428571e-09 0.03333333333333333 \
 5.772428571428572e-09 -0.03333333333333333 \
 5.780357142857143e-09 -0.03333333333333333 \
 5.781357142857144e-09 0.03333333333333333 \
 5.789285714285714e-09 0.03333333333333333 \
 5.790285714285715e-09 -0.1 \
 5.798214285714286e-09 -0.1 \
 5.799214285714286e-09 0.1 \
 5.807142857142857e-09 0.1 \
 5.808142857142857e-09 0.03333333333333333 \
 5.816071428571429e-09 0.03333333333333333 \
 5.817071428571429e-09 0.03333333333333333 \
 5.825e-09 0.03333333333333333 \
 5.826e-09 0.03333333333333333 \
 5.833928571428571e-09 0.03333333333333333 \
 5.834928571428571e-09 0.1 \
 5.842857142857143e-09 0.1 \
 5.843857142857143e-09 0.1 \
 5.851785714285714e-09 0.1 \
 5.852785714285714e-09 -0.03333333333333333 \
 5.860714285714286e-09 -0.03333333333333333 \
 5.861714285714286e-09 0.03333333333333333 \
 5.869642857142857e-09 0.03333333333333333 \
 5.870642857142857e-09 0.1 \
 5.878571428571429e-09 0.1 \
 5.879571428571429e-09 -0.1 \
 5.8875e-09 -0.1 \
 5.8885e-09 0.03333333333333333 \
 5.896428571428572e-09 0.03333333333333333 \
 5.897428571428572e-09 0.03333333333333333 \
 5.905357142857143e-09 0.03333333333333333 \
 5.906357142857143e-09 -0.1 \
 5.914285714285715e-09 -0.1 \
 5.915285714285715e-09 0.1 \
 5.923214285714286e-09 0.1 \
 5.924214285714286e-09 -0.1 \
 5.932142857142857e-09 -0.1 \
 5.933142857142858e-09 0.03333333333333333 \
 5.941071428571428e-09 0.03333333333333333 \
 5.942071428571429e-09 0.03333333333333333 \
 5.95e-09 0.03333333333333333 \
 5.951000000000001e-09 -0.1 \
 5.958928571428571e-09 -0.1 \
 5.959928571428572e-09 0.03333333333333333 \
 5.967857142857143e-09 0.03333333333333333 \
 5.968857142857144e-09 0.1 \
 5.976785714285714e-09 0.1 \
 5.977785714285715e-09 0.03333333333333333 \
 5.985714285714286e-09 0.03333333333333333 \
 5.986714285714286e-09 -0.03333333333333333 \
 5.994642857142857e-09 -0.03333333333333333 \
 5.995642857142857e-09 -0.1 \
 6.003571428571428e-09 -0.1 \
 6.004571428571429e-09 0.1 \
 6.0125e-09 0.1 \
 6.0135e-09 -0.1 \
 6.021428571428571e-09 -0.1 \
 6.022428571428571e-09 -0.03333333333333333 \
 6.030357142857143e-09 -0.03333333333333333 \
 6.031357142857143e-09 0.03333333333333333 \
 6.039285714285714e-09 0.03333333333333333 \
 6.040285714285714e-09 0.03333333333333333 \
 6.048214285714286e-09 0.03333333333333333 \
 6.049214285714286e-09 -0.03333333333333333 \
 6.057142857142857e-09 -0.03333333333333333 \
 6.058142857142857e-09 -0.1 \
 6.066071428571429e-09 -0.1 \
 6.067071428571429e-09 -0.03333333333333333 \
 6.075e-09 -0.03333333333333333 \
 6.076e-09 -0.03333333333333333 \
 6.083928571428572e-09 -0.03333333333333333 \
 6.084928571428572e-09 0.03333333333333333 \
 6.092857142857143e-09 0.03333333333333333 \
 6.093857142857143e-09 -0.03333333333333333 \
 6.101785714285715e-09 -0.03333333333333333 \
 6.102785714285715e-09 -0.1 \
 6.110714285714286e-09 -0.1 \
 6.111714285714286e-09 0.1 \
 6.119642857142857e-09 0.1 \
 6.120642857142858e-09 0.03333333333333333 \
 6.128571428571429e-09 0.03333333333333333 \
 6.129571428571429e-09 0.1 \
 6.1375e-09 0.1 \
 6.138500000000001e-09 0.1 \
 6.146428571428571e-09 0.1 \
 6.147428571428572e-09 -0.03333333333333333 \
 6.155357142857143e-09 -0.03333333333333333 \
 6.156357142857144e-09 -0.03333333333333333 \
 6.164285714285714e-09 -0.03333333333333333 \
 6.165285714285715e-09 0.03333333333333333 \
 6.173214285714286e-09 0.03333333333333333 \
 6.174214285714286e-09 -0.03333333333333333 \
 6.182142857142857e-09 -0.03333333333333333 \
 6.183142857142858e-09 0.03333333333333333 \
 6.191071428571428e-09 0.03333333333333333 \
 6.192071428571429e-09 -0.1 \
 6.2e-09 -0.1 \
 6.201e-09 0.03333333333333333 \
 6.208928571428571e-09 0.03333333333333333 \
 6.209928571428571e-09 -0.03333333333333333 \
 6.217857142857143e-09 -0.03333333333333333 \
 6.218857142857143e-09 -0.03333333333333333 \
 6.226785714285714e-09 -0.03333333333333333 \
 6.227785714285714e-09 0.03333333333333333 \
 6.235714285714286e-09 0.03333333333333333 \
 6.236714285714286e-09 -0.03333333333333333 \
 6.244642857142857e-09 -0.03333333333333333 \
 6.245642857142857e-09 0.1 \
 6.253571428571429e-09 0.1 \
 6.254571428571429e-09 0.03333333333333333 \
 6.2625e-09 0.03333333333333333 \
 6.2635e-09 -0.1 \
 6.271428571428572e-09 -0.1 \
 6.272428571428572e-09 -0.03333333333333333 \
 6.280357142857143e-09 -0.03333333333333333 \
 6.281357142857143e-09 0.03333333333333333 \
 6.289285714285715e-09 0.03333333333333333 \
 6.290285714285715e-09 0.03333333333333333 \
 6.298214285714286e-09 0.03333333333333333 \
 6.299214285714286e-09 0.03333333333333333 \
 6.307142857142857e-09 0.03333333333333333 \
 6.308142857142858e-09 0.1 \
 6.316071428571429e-09 0.1 \
 6.317071428571429e-09 -0.03333333333333333 \
 6.325e-09 -0.03333333333333333 \
 6.326000000000001e-09 0.1 \
 6.333928571428571e-09 0.1 \
 6.334928571428572e-09 0.1 \
 6.342857142857143e-09 0.1 \
 6.343857142857144e-09 -0.03333333333333333 \
 6.351785714285714e-09 -0.03333333333333333 \
 6.352785714285715e-09 0.1 \
 6.360714285714285e-09 0.1 \
 6.361714285714286e-09 0.1 \
 6.369642857142857e-09 0.1 \
 6.370642857142858e-09 -0.1 \
 6.378571428571428e-09 -0.1 \
 6.379571428571429e-09 0.1 \
 6.3875e-09 0.1 \
 6.3885e-09 -0.03333333333333333 \
 6.396428571428571e-09 -0.03333333333333333 \
 6.397428571428571e-09 -0.1 \
 6.405357142857143e-09 -0.1 \
 6.406357142857143e-09 -0.03333333333333333 \
 6.414285714285714e-09 -0.03333333333333333 \
 6.415285714285714e-09 0.1 \
 6.423214285714286e-09 0.1 \
 6.424214285714286e-09 -0.03333333333333333 \
 6.432142857142857e-09 -0.03333333333333333 \
 6.433142857142857e-09 0.1 \
 6.441071428571429e-09 0.1 \
 6.442071428571429e-09 0.03333333333333333 \
 6.45e-09 0.03333333333333333 \
 6.451e-09 -0.03333333333333333 \
 6.458928571428572e-09 -0.03333333333333333 \
 6.459928571428572e-09 0.03333333333333333 \
 6.467857142857143e-09 0.03333333333333333 \
 6.468857142857143e-09 -0.1 \
 6.476785714285715e-09 -0.1 \
 6.477785714285715e-09 0.03333333333333333 \
 6.485714285714286e-09 0.03333333333333333 \
 6.486714285714286e-09 -0.03333333333333333 \
 6.494642857142858e-09 -0.03333333333333333 \
 6.495642857142858e-09 0.1 \
 6.503571428571429e-09 0.1 \
 6.504571428571429e-09 -0.1 \
 6.5125e-09 -0.1 \
 6.513500000000001e-09 0.1 \
 6.521428571428571e-09 0.1 \
 6.522428571428572e-09 0.1 \
 6.530357142857142e-09 0.1 \
 6.531357142857143e-09 -0.03333333333333333 \
 6.539285714285714e-09 -0.03333333333333333 \
 6.540285714285715e-09 -0.1 \
 6.548214285714285e-09 -0.1 \
 6.549214285714286e-09 -0.03333333333333333 \
 6.557142857142857e-09 -0.03333333333333333 \
 6.558142857142858e-09 0.1 \
 6.566071428571428e-09 0.1 \
 6.567071428571429e-09 0.03333333333333333 \
 6.575e-09 0.03333333333333333 \
 6.576e-09 0.1 \
 6.583928571428571e-09 0.1 \
 6.584928571428571e-09 0.1 \
 6.592857142857143e-09 0.1 \
 6.593857142857143e-09 0.1 \
 6.601785714285714e-09 0.1 \
 6.602785714285714e-09 0.1 \
 6.610714285714286e-09 0.1 \
 6.611714285714286e-09 -0.03333333333333333 \
 6.619642857142857e-09 -0.03333333333333333 \
 6.620642857142857e-09 0.03333333333333333 \
 6.628571428571429e-09 0.03333333333333333 \
 6.629571428571429e-09 0.1 \
 6.6375e-09 0.1 \
 6.6385e-09 0.1 \
 6.646428571428572e-09 0.1 \
 6.647428571428572e-09 -0.03333333333333333 \
 6.655357142857143e-09 -0.03333333333333333 \
 6.656357142857143e-09 -0.03333333333333333 \
 6.664285714285715e-09 -0.03333333333333333 \
 6.665285714285715e-09 -0.1 \
 6.673214285714286e-09 -0.1 \
 6.674214285714286e-09 0.1 \
 6.682142857142858e-09 0.1 \
 6.683142857142858e-09 -0.03333333333333333 \
 6.691071428571429e-09 -0.03333333333333333 \
 6.692071428571429e-09 0.03333333333333333 \
 6.7e-09 0.03333333333333333 \
 6.701000000000001e-09 0.1 \
 6.708928571428571e-09 0.1 \
 6.709928571428572e-09 0.03333333333333333 \
 6.717857142857143e-09 0.03333333333333333 \
 6.718857142857143e-09 -0.03333333333333333 \
 6.726785714285714e-09 -0.03333333333333333 \
 6.727785714285715e-09 -0.03333333333333333 \
 6.735714285714285e-09 -0.03333333333333333 \
 6.736714285714286e-09 0.03333333333333333 \
 6.744642857142857e-09 0.03333333333333333 \
 6.745642857142858e-09 0.03333333333333333 \
 6.753571428571428e-09 0.03333333333333333 \
 6.754571428571429e-09 -0.03333333333333333 \
 6.7625e-09 -0.03333333333333333 \
 6.7635e-09 -0.03333333333333333 \
 6.771428571428571e-09 -0.03333333333333333 \
 6.772428571428572e-09 0.03333333333333333 \
 6.780357142857143e-09 0.03333333333333333 \
 6.781357142857143e-09 0.1 \
 6.789285714285714e-09 0.1 \
 6.790285714285714e-09 -0.1 \
 6.798214285714286e-09 -0.1 \
 6.799214285714286e-09 -0.03333333333333333 \
 6.807142857142857e-09 -0.03333333333333333 \
 6.808142857142857e-09 -0.1 \
 6.816071428571429e-09 -0.1 \
 6.817071428571429e-09 -0.1 \
 6.825e-09 -0.1 \
 6.826e-09 0.1 \
 6.833928571428572e-09 0.1 \
 6.834928571428572e-09 0.1 \
 6.842857142857143e-09 0.1 \
 6.843857142857143e-09 -0.1 \
 6.851785714285715e-09 -0.1 \
 6.852785714285715e-09 0.1 \
 6.860714285714286e-09 0.1 \
 6.861714285714286e-09 -0.1 \
 6.869642857142858e-09 -0.1 \
 6.870642857142858e-09 -0.03333333333333333 \
 6.878571428571429e-09 -0.03333333333333333 \
 6.879571428571429e-09 -0.1 \
 6.8875e-09 -0.1 \
 6.8885e-09 -0.1 \
 6.896428571428571e-09 -0.1 \
 6.897428571428572e-09 -0.1 \
 6.905357142857143e-09 -0.1 \
 6.906357142857143e-09 0.1 \
 6.914285714285714e-09 0.1 \
 6.915285714285715e-09 -0.03333333333333333 \
 6.923214285714285e-09 -0.03333333333333333 \
 6.924214285714286e-09 0.03333333333333333 \
 6.932142857142857e-09 0.03333333333333333 \
 6.933142857142858e-09 -0.03333333333333333 \
 6.941071428571428e-09 -0.03333333333333333 \
 6.942071428571429e-09 -0.1 \
 6.95e-09 -0.1 \
 6.951000000000001e-09 -0.03333333333333333 \
 6.958928571428571e-09 -0.03333333333333333 \
 6.959928571428572e-09 0.03333333333333333 \
 6.967857142857143e-09 0.03333333333333333 \
 6.968857142857143e-09 -0.1 \
 6.976785714285714e-09 -0.1 \
 6.977785714285714e-09 -0.03333333333333333 \
 6.985714285714286e-09 -0.03333333333333333 \
 6.986714285714286e-09 0.03333333333333333 \
 6.994642857142857e-09 0.03333333333333333 \
 6.995642857142857e-09 0.1 \
 7.003571428571429e-09 0.1 \
 7.004571428571429e-09 0.1 \
 7.0125e-09 0.1 \
 7.0135e-09 -0.1 \
 7.021428571428572e-09 -0.1 \
 7.022428571428572e-09 -0.1 \
 7.030357142857143e-09 -0.1 \
 7.031357142857143e-09 -0.03333333333333333 \
 7.039285714285715e-09 -0.03333333333333333 \
 7.040285714285715e-09 0.1 \
 7.048214285714286e-09 0.1 \
 7.049214285714286e-09 -0.03333333333333333 \
 7.057142857142857e-09 -0.03333333333333333 \
 7.058142857142857e-09 -0.03333333333333333 \
 7.066071428571429e-09 -0.03333333333333333 \
 7.067071428571429e-09 -0.1 \
 7.075e-09 -0.1 \
 7.076e-09 -0.03333333333333333 \
 7.083928571428572e-09 -0.03333333333333333 \
 7.084928571428572e-09 -0.1 \
 7.092857142857143e-09 -0.1 \
 7.093857142857143e-09 0.03333333333333333 \
 7.101785714285714e-09 0.03333333333333333 \
 7.102785714285715e-09 0.1 \
 7.110714285714285e-09 0.1 \
 7.111714285714286e-09 0.1 \
 7.119642857142857e-09 0.1 \
 7.120642857142858e-09 0.03333333333333333 \
 7.128571428571428e-09 0.03333333333333333 \
 7.129571428571429e-09 0.1 \
 7.1375e-09 0.1 \
 7.138500000000001e-09 0.03333333333333333 \
 7.146428571428571e-09 0.03333333333333333 \
 7.147428571428572e-09 0.1 \
 7.155357142857143e-09 0.1 \
 7.156357142857143e-09 0.03333333333333333 \
 7.164285714285714e-09 0.03333333333333333 \
 7.165285714285714e-09 0.03333333333333333 \
 7.173214285714286e-09 0.03333333333333333 \
 7.174214285714286e-09 0.03333333333333333 \
 7.182142857142857e-09 0.03333333333333333 \
 7.183142857142857e-09 0.1 \
 7.191071428571429e-09 0.1 \
 7.192071428571429e-09 0.03333333333333333 \
 7.2e-09 0.03333333333333333 \
 7.201e-09 0.03333333333333333 \
 7.208928571428572e-09 0.03333333333333333 \
 7.209928571428572e-09 -0.03333333333333333 \
 7.217857142857143e-09 -0.03333333333333333 \
 7.218857142857143e-09 0.1 \
 7.226785714285715e-09 0.1 \
 7.227785714285715e-09 0.03333333333333333 \
 7.235714285714286e-09 0.03333333333333333 \
 7.236714285714286e-09 0.1 \
 7.244642857142857e-09 0.1 \
 7.245642857142857e-09 0.1 \
 7.253571428571429e-09 0.1 \
 7.254571428571429e-09 0.1 \
 7.2625e-09 0.1 \
 7.2635e-09 -0.1 \
 7.271428571428572e-09 -0.1 \
 7.272428571428572e-09 -0.1 \
 7.280357142857143e-09 -0.1 \
 7.281357142857143e-09 -0.03333333333333333 \
 7.289285714285714e-09 -0.03333333333333333 \
 7.290285714285715e-09 -0.1 \
 7.298214285714285e-09 -0.1 \
 7.299214285714286e-09 -0.1 \
 7.307142857142857e-09 -0.1 \
 7.308142857142858e-09 -0.1 \
 7.316071428571428e-09 -0.1 \
 7.317071428571429e-09 0.1 \
 7.325e-09 0.1 \
 7.326000000000001e-09 -0.03333333333333333 \
 7.333928571428571e-09 -0.03333333333333333 \
 7.334928571428572e-09 0.03333333333333333 \
 7.342857142857143e-09 0.03333333333333333 \
 7.343857142857143e-09 0.03333333333333333 \
 7.351785714285714e-09 0.03333333333333333 \
 7.352785714285714e-09 0.1 \
 7.360714285714286e-09 0.1 \
 7.361714285714286e-09 -0.1 \
 7.369642857142857e-09 -0.1 \
 7.370642857142857e-09 -0.1 \
 7.378571428571429e-09 -0.1 \
 7.379571428571429e-09 0.03333333333333333 \
 7.3875e-09 0.03333333333333333 \
 7.3885e-09 -0.03333333333333333 \
 7.396428571428572e-09 -0.03333333333333333 \
 7.397428571428572e-09 -0.1 \
 7.405357142857143e-09 -0.1 \
 7.406357142857143e-09 -0.1 \
 7.414285714285714e-09 -0.1 \
 7.415285714285714e-09 -0.1 \
 7.423214285714286e-09 -0.1 \
 7.424214285714286e-09 -0.03333333333333333 \
 7.432142857142857e-09 -0.03333333333333333 \
 7.433142857142857e-09 0.1 \
 7.441071428571429e-09 0.1 \
 7.442071428571429e-09 -0.03333333333333333 \
 7.45e-09 -0.03333333333333333 \
 7.451e-09 -0.1 \
 7.458928571428571e-09 -0.1 \
 7.45992857142857e-09 0.1 \
 7.467857142857143e-09 0.1 \
 7.468857142857142e-09 -0.1 \
 7.476785714285714e-09 -0.1 \
 7.477785714285714e-09 0.03333333333333333 \
 7.485714285714285e-09 0.03333333333333333 \
 7.486714285714284e-09 0.03333333333333333 \
 7.494642857142857e-09 0.03333333333333333 \
 7.495642857142856e-09 0.1 \
 7.503571428571428e-09 0.1 \
 7.504571428571428e-09 -0.1 \
 7.5125e-09 -0.1 \
 7.5135e-09 -0.1 \
 7.52142857142857e-09 -0.1 \
 7.52242857142857e-09 0.1 \
 7.530357142857142e-09 0.1 \
 7.531357142857142e-09 0.1 \
 7.539285714285714e-09 0.1 \
 7.540285714285714e-09 0.1 \
 7.548214285714286e-09 0.1 \
 7.549214285714286e-09 -0.1 \
 7.557142857142856e-09 -0.1 \
 7.558142857142856e-09 0.03333333333333333 \
 7.566071428571428e-09 0.03333333333333333 \
 7.567071428571428e-09 0.1 \
 7.575e-09 0.1 \
 7.575999999999999e-09 -0.03333333333333333 \
 7.583928571428572e-09 -0.03333333333333333 \
 7.584928571428571e-09 0.03333333333333333 \
 7.592857142857142e-09 0.03333333333333333 \
 7.593857142857142e-09 0.03333333333333333 \
 7.601785714285714e-09 0.03333333333333333 \
 7.602785714285713e-09 0.1 \
 7.610714285714286e-09 0.1 \
 7.611714285714285e-09 -0.03333333333333333 \
 7.619642857142856e-09 -0.03333333333333333 \
 7.620642857142855e-09 0.03333333333333333 \
 7.628571428571428e-09 0.03333333333333333 \
 7.629571428571427e-09 -0.1 \
 7.6375e-09 -0.1 \
 7.638499999999999e-09 -0.1 \
 7.646428571428572e-09 -0.1 \
 7.647428571428571e-09 0.1 \
 7.655357142857143e-09 0.1 \
 7.656357142857143e-09 -0.03333333333333333 \
 7.664285714285714e-09 -0.03333333333333333 \
 7.665285714285713e-09 0.03333333333333333 \
 7.673214285714286e-09 0.03333333333333333 \
 7.674214285714285e-09 -0.03333333333333333 \
 7.682142857142857e-09 -0.03333333333333333 \
 7.683142857142857e-09 0.03333333333333333 \
 7.691071428571429e-09 0.03333333333333333 \
 7.692071428571429e-09 0.03333333333333333 \
 7.699999999999999e-09 0.03333333333333333 \
 7.700999999999999e-09 -0.1 \
 7.708928571428571e-09 -0.1 \
 7.709928571428571e-09 0.1 \
 7.717857142857143e-09 0.1 \
 7.718857142857143e-09 -0.03333333333333333 \
 7.726785714285715e-09 -0.03333333333333333 \
 7.727785714285715e-09 0.1 \
 7.735714285714285e-09 0.1 \
 7.736714285714285e-09 0.03333333333333333 \
 7.744642857142857e-09 0.03333333333333333 \
 7.745642857142857e-09 -0.1 \
 7.753571428571429e-09 -0.1 \
 7.754571428571428e-09 0.03333333333333333 \
 7.762499999999999e-09 0.03333333333333333 \
 7.763499999999999e-09 -0.1 \
 7.771428571428571e-09 -0.1 \
 7.772428571428571e-09 -0.1 \
 7.780357142857143e-09 -0.1 \
 7.781357142857142e-09 0.1 \
 7.789285714285715e-09 0.1 \
 7.790285714285714e-09 -0.1 \
 7.798214285714285e-09 -0.1 \
 7.799214285714284e-09 -0.03333333333333333 \
 7.807142857142857e-09 -0.03333333333333333 \
 7.808142857142856e-09 -0.03333333333333333 \
 7.816071428571429e-09 -0.03333333333333333 \
 7.817071428571428e-09 0.1 \
 7.825000000000001e-09 0.1 \
 7.826e-09 0.1 \
 7.833928571428571e-09 0.1 \
 7.83492857142857e-09 0.03333333333333333 \
 7.842857142857143e-09 0.03333333333333333 \
 7.843857142857142e-09 0.03333333333333333 \
 7.851785714285715e-09 0.03333333333333333 \
 7.852785714285714e-09 0.03333333333333333 \
 7.860714285714286e-09 0.03333333333333333 \
 7.861714285714286e-09 -0.1 \
 7.869642857142857e-09 -0.1 \
 7.870642857142856e-09 0.1 \
 7.878571428571428e-09 0.1 \
 7.879571428571428e-09 -0.1 \
 7.8875e-09 -0.1 \
 7.8885e-09 -0.03333333333333333 \
 7.896428571428572e-09 -0.03333333333333333 \
 7.897428571428572e-09 0.1 \
 7.905357142857142e-09 0.1 \
 7.906357142857142e-09 -0.03333333333333333 \
 7.914285714285714e-09 -0.03333333333333333 \
 7.915285714285714e-09 -0.03333333333333333 \
 7.923214285714286e-09 -0.03333333333333333 \
 7.924214285714286e-09 -0.1 \
 7.932142857142858e-09 -0.1 \
 7.933142857142857e-09 0.03333333333333333 \
 7.941071428571428e-09 0.03333333333333333 \
 7.942071428571428e-09 0.1 \
 7.95e-09 0.1 \
 7.951e-09 0.03333333333333333 \
 7.958928571428572e-09 0.03333333333333333 \
 7.959928571428571e-09 0.1 \
 7.967857142857142e-09 0.1 \
 7.968857142857142e-09 0.1 \
 7.976785714285714e-09 0.1 \
 7.977785714285713e-09 0.03333333333333333 \
 7.985714285714286e-09 0.03333333333333333 \
 7.986714285714285e-09 0.1 \
 7.994642857142858e-09 0.1 \
 7.995642857142857e-09 0.1 \
 8.003571428571428e-09 0.1 \
 8.004571428571427e-09 -0.1 \
 8.0125e-09 -0.1 \
 8.013499999999999e-09 -0.03333333333333333 \
 8.021428571428572e-09 -0.03333333333333333 \
 8.022428571428571e-09 -0.1 \
 8.030357142857144e-09 -0.1 \
 8.031357142857143e-09 0.1 \
 8.039285714285714e-09 0.1 \
 8.040285714285713e-09 -0.03333333333333333 \
 8.048214285714286e-09 -0.03333333333333333 \
 8.049214285714285e-09 -0.03333333333333333 \
 8.057142857142857e-09 -0.03333333333333333 \
 8.058142857142857e-09 0.1 \
 8.066071428571429e-09 0.1 \
 8.067071428571429e-09 0.03333333333333333 \
 8.075e-09 0.03333333333333333 \
 8.075999999999999e-09 -0.03333333333333333 \
 8.083928571428571e-09 -0.03333333333333333 \
 8.084928571428571e-09 -0.03333333333333333 \
 8.092857142857143e-09 -0.03333333333333333 \
 8.093857142857143e-09 0.1 \
 8.101785714285715e-09 0.1 \
 8.102785714285715e-09 0.1 \
 8.110714285714285e-09 0.1 \
 8.111714285714285e-09 0.03333333333333333 \
 8.119642857142857e-09 0.03333333333333333 \
 8.120642857142857e-09 0.1 \
 8.128571428571429e-09 0.1 \
 8.129571428571429e-09 -0.1 \
 8.137499999999999e-09 -0.1 \
 8.138499999999999e-09 0.03333333333333333 \
 8.146428571428571e-09 0.03333333333333333 \
 8.147428571428571e-09 0.1 \
 8.155357142857143e-09 0.1 \
 8.156357142857142e-09 0.1 \
 8.164285714285715e-09 0.1 \
 8.165285714285714e-09 0.03333333333333333 \
 8.173214285714285e-09 0.03333333333333333 \
 8.174214285714285e-09 0.03333333333333333 \
 8.182142857142857e-09 0.03333333333333333 \
 8.183142857142856e-09 0.1 \
 8.191071428571429e-09 0.1 \
 8.192071428571428e-09 -0.1 \
 8.200000000000001e-09 -0.1 \
 8.201e-09 0.1 \
 8.208928571428571e-09 0.1 \
 8.20992857142857e-09 0.1 \
 8.217857142857143e-09 0.1 \
 8.218857142857142e-09 0.03333333333333333 \
 8.226785714285715e-09 0.03333333333333333 \
 8.227785714285714e-09 -0.03333333333333333 \
 8.235714285714286e-09 -0.03333333333333333 \
 8.236714285714286e-09 -0.03333333333333333 \
 8.244642857142857e-09 -0.03333333333333333 \
 8.245642857142856e-09 -0.03333333333333333 \
 8.253571428571429e-09 -0.03333333333333333 \
 8.254571428571428e-09 -0.1 \
 8.2625e-09 -0.1 \
 8.2635e-09 -0.1 \
 8.271428571428572e-09 -0.1 \
 8.272428571428572e-09 0.03333333333333333 \
 8.280357142857142e-09 0.03333333333333333 \
 8.281357142857142e-09 -0.1 \
 8.289285714285714e-09 -0.1 \
 8.290285714285714e-09 -0.1 \
 8.298214285714286e-09 -0.1 \
 8.299214285714286e-09 0.03333333333333333 \
 8.307142857142856e-09 0.03333333333333333 \
 8.308142857142856e-09 0.03333333333333333 \
 8.316071428571428e-09 0.03333333333333333 \
 8.317071428571428e-09 0.03333333333333333 \
 8.325e-09 0.03333333333333333 \
 8.326e-09 -0.03333333333333333 \
 8.333928571428572e-09 -0.03333333333333333 \
 8.334928571428571e-09 -0.1 \
 8.342857142857142e-09 -0.1 \
 8.343857142857142e-09 -0.03333333333333333 \
 8.351785714285714e-09 -0.03333333333333333 \
 8.352785714285714e-09 0.03333333333333333 \
 8.360714285714286e-09 0.03333333333333333 \
 8.361714285714285e-09 0.1 \
 8.369642857142858e-09 0.1 \
 8.370642857142857e-09 0.1 \
 8.378571428571428e-09 0.1 \
 8.379571428571427e-09 0.03333333333333333 \
 8.3875e-09 0.03333333333333333 \
 8.388499999999999e-09 0.1 \
 8.396428571428572e-09 0.1 \
 8.397428571428571e-09 -0.03333333333333333 \
 8.405357142857144e-09 -0.03333333333333333 \
 8.406357142857143e-09 0.1 \
 8.414285714285714e-09 0.1 \
 8.415285714285713e-09 -0.03333333333333333 \
 8.423214285714286e-09 -0.03333333333333333 \
 8.424214285714285e-09 -0.1 \
 8.432142857142857e-09 -0.1 \
 8.433142857142857e-09 -0.03333333333333333 \
 8.441071428571429e-09 -0.03333333333333333 \
 8.442071428571429e-09 -0.03333333333333333 \
 8.45e-09 -0.03333333333333333 \
 8.450999999999999e-09 -0.03333333333333333 \
 8.458928571428571e-09 -0.03333333333333333 \
 8.459928571428571e-09 -0.1 \
 8.467857142857143e-09 -0.1 \
 8.468857142857143e-09 0.03333333333333333 \
 8.476785714285713e-09 0.03333333333333333 \
 8.477785714285713e-09 0.1 \
 8.485714285714285e-09 0.1 \
 8.486714285714285e-09 -0.03333333333333333 \
 8.494642857142857e-09 -0.03333333333333333 \
 8.495642857142857e-09 0.03333333333333333 \
 8.503571428571429e-09 0.03333333333333333 \
 8.504571428571429e-09 0.1 \
 8.512499999999999e-09 0.1 \
 8.513499999999999e-09 -0.1 \
 8.521428571428571e-09 -0.1 \
 8.522428571428571e-09 -0.03333333333333333 \
 8.530357142857143e-09 -0.03333333333333333 \
 8.531357142857143e-09 -0.03333333333333333 \
 8.539285714285715e-09 -0.03333333333333333 \
 8.540285714285714e-09 -0.03333333333333333 \
 8.548214285714285e-09 -0.03333333333333333 \
 8.549214285714285e-09 -0.1 \
 8.557142857142857e-09 -0.1 \
 8.558142857142856e-09 -0.03333333333333333 \
 8.566071428571429e-09 -0.03333333333333333 \
 8.567071428571428e-09 0.1 \
 8.575000000000001e-09 0.1 \
 8.576e-09 0.1 \
 8.583928571428571e-09 0.1 \
 8.58492857142857e-09 -0.1 \
 8.592857142857143e-09 -0.1 \
 8.593857142857142e-09 0.03333333333333333 \
 8.601785714285715e-09 0.03333333333333333 \
 8.602785714285714e-09 -0.1 \
 8.610714285714286e-09 -0.1 \
 8.611714285714286e-09 0.03333333333333333 \
 8.619642857142857e-09 0.03333333333333333 \
 8.620642857142856e-09 0.1 \
 8.628571428571429e-09 0.1 \
 8.629571428571428e-09 -0.1 \
 8.6375e-09 -0.1 \
 8.6385e-09 0.03333333333333333 \
 8.646428571428571e-09 0.03333333333333333 \
 8.64742857142857e-09 -0.1 \
 8.655357142857142e-09 -0.1 \
 8.656357142857142e-09 -0.03333333333333333 \
 8.664285714285714e-09 -0.03333333333333333 \
 8.665285714285714e-09 0.1 \
 8.673214285714286e-09 0.1 \
 8.674214285714286e-09 -0.1 \
 8.682142857142856e-09 -0.1 \
 8.683142857142856e-09 -0.1 \
 8.691071428571428e-09 -0.1 \
 8.692071428571428e-09 0.1 \
 8.7e-09 0.1 \
 8.701e-09 -0.1 \
 8.708928571428572e-09 -0.1 \
 8.709928571428571e-09 -0.03333333333333333 \
 8.717857142857142e-09 -0.03333333333333333 \
 8.718857142857142e-09 -0.03333333333333333 \
 8.726785714285714e-09 -0.03333333333333333 \
 8.727785714285714e-09 -0.03333333333333333 \
 8.735714285714286e-09 -0.03333333333333333 \
 8.736714285714285e-09 0.03333333333333333 \
 8.744642857142858e-09 0.03333333333333333 \
 8.745642857142857e-09 -0.03333333333333333 \
 8.753571428571428e-09 -0.03333333333333333 \
 8.754571428571427e-09 0.03333333333333333 \
 8.7625e-09 0.03333333333333333 \
 8.763499999999999e-09 -0.03333333333333333 \
 8.771428571428572e-09 -0.03333333333333333 \
 8.772428571428571e-09 -0.03333333333333333 \
 8.780357142857144e-09 -0.03333333333333333 \
 8.781357142857143e-09 -0.03333333333333333 \
 8.789285714285714e-09 -0.03333333333333333 \
 8.790285714285713e-09 -0.1 \
 8.798214285714286e-09 -0.1 \
 8.799214285714285e-09 0.03333333333333333 \
 8.807142857142858e-09 0.03333333333333333 \
 8.808142857142857e-09 -0.1 \
 8.816071428571428e-09 -0.1 \
 8.817071428571427e-09 0.03333333333333333 \
 8.825e-09 0.03333333333333333 \
 8.825999999999999e-09 -0.03333333333333333 \
 8.833928571428571e-09 -0.03333333333333333 \
 8.834928571428571e-09 -0.1 \
 8.842857142857143e-09 -0.1 \
 8.843857142857143e-09 0.1 \
 8.851785714285714e-09 0.1 \
 8.852785714285713e-09 -0.1 \
 8.860714285714285e-09 -0.1 \
 8.861714285714285e-09 0.1 \
 8.869642857142857e-09 0.1 \
 8.870642857142857e-09 0.1 \
 8.878571428571429e-09 0.1 \
 8.879571428571429e-09 0.1 \
 8.887499999999999e-09 0.1 \
 8.888499999999999e-09 0.1 \
 8.896428571428571e-09 0.1 \
 8.897428571428571e-09 -0.03333333333333333 \
 8.905357142857143e-09 -0.03333333333333333 \
 8.906357142857143e-09 0.03333333333333333 \
 8.914285714285715e-09 0.03333333333333333 \
 8.915285714285714e-09 -0.03333333333333333 \
 8.923214285714285e-09 -0.03333333333333333 \
 8.924214285714285e-09 0.03333333333333333 \
 8.932142857142857e-09 0.03333333333333333 \
 8.933142857142856e-09 0.03333333333333333 \
 8.941071428571429e-09 0.03333333333333333 \
 8.942071428571428e-09 0.1 \
 8.950000000000001e-09 0.1 \
 8.951e-09 -0.1 \
 8.958928571428571e-09 -0.1 \
 8.95992857142857e-09 -0.1 \
 8.967857142857143e-09 -0.1 \
 8.968857142857142e-09 -0.03333333333333333 \
 8.976785714285715e-09 -0.03333333333333333 \
 8.977785714285714e-09 0.03333333333333333 \
 8.985714285714287e-09 0.03333333333333333 \
 8.986714285714286e-09 0.03333333333333333 \
 8.994642857142857e-09 0.03333333333333333 \
 8.995642857142856e-09 0.1 \
 9.003571428571429e-09 0.1 \
 9.004571428571428e-09 -0.03333333333333333 \
 9.0125e-09 -0.03333333333333333 \
 9.0135e-09 -0.03333333333333333 \
 9.021428571428571e-09 -0.03333333333333333 \
 9.02242857142857e-09 -0.03333333333333333 \
 9.030357142857143e-09 -0.03333333333333333 \
 9.031357142857142e-09 0.1 \
 9.039285714285714e-09 0.1 \
 9.040285714285714e-09 0.03333333333333333 \
 9.048214285714286e-09 0.03333333333333333 \
 9.049214285714286e-09 -0.03333333333333333 \
 9.057142857142856e-09 -0.03333333333333333 \
 9.058142857142856e-09 0.1 \
 9.066071428571428e-09 0.1 \
 9.067071428571428e-09 -0.03333333333333333 \
 9.075e-09 -0.03333333333333333 \
 9.076e-09 -0.1 \
 9.083928571428572e-09 -0.1 \
 9.084928571428572e-09 0.1 \
 9.092857142857142e-09 0.1 \
 9.093857142857142e-09 -0.1 \
 9.101785714285714e-09 -0.1 \
 9.102785714285714e-09 -0.1 \
 9.110714285714286e-09 -0.1 \
 9.111714285714285e-09 0.1 \
 9.119642857142858e-09 0.1 \
 9.120642857142857e-09 0.03333333333333333 \
 9.128571428571428e-09 0.03333333333333333 \
 9.129571428571428e-09 0.1 \
 9.1375e-09 0.1 \
 9.138499999999999e-09 0.1 \
 9.146428571428572e-09 0.1 \
 9.147428571428571e-09 0.1 \
 9.155357142857144e-09 0.1 \
 9.156357142857143e-09 0.1 \
 9.164285714285714e-09 0.1 \
 9.165285714285713e-09 0.1 \
 9.173214285714286e-09 0.1 \
 9.174214285714285e-09 -0.03333333333333333 \
 9.182142857142858e-09 -0.03333333333333333 \
 9.183142857142857e-09 -0.03333333333333333 \
 9.191071428571428e-09 -0.03333333333333333 \
 9.192071428571427e-09 0.03333333333333333 \
 9.2e-09 0.03333333333333333 \
 9.200999999999999e-09 -0.03333333333333333 \
 9.208928571428572e-09 -0.03333333333333333 \
 9.209928571428571e-09 -0.03333333333333333 \
 9.217857142857143e-09 -0.03333333333333333 \
 9.218857142857143e-09 -0.1 \
 9.226785714285714e-09 -0.1 \
 9.227785714285713e-09 0.1 \
 9.235714285714285e-09 0.1 \
 9.236714285714285e-09 0.03333333333333333 \
 9.244642857142857e-09 0.03333333333333333 \
 9.245642857142857e-09 -0.03333333333333333 \
 9.253571428571429e-09 -0.03333333333333333 \
 9.254571428571429e-09 -0.1 \
 9.262499999999999e-09 -0.1 \
 9.263499999999999e-09 -0.03333333333333333 \
 9.271428571428571e-09 -0.03333333333333333 \
 9.272428571428571e-09 0.03333333333333333 \
 9.280357142857143e-09 0.03333333333333333 \
 9.281357142857143e-09 -0.1 \
 9.289285714285715e-09 -0.1 \
 9.290285714285714e-09 -0.03333333333333333 \
 9.298214285714285e-09 -0.03333333333333333 \
 9.299214285714285e-09 -0.1 \
 9.307142857142857e-09 -0.1 \
 9.308142857142857e-09 0.03333333333333333 \
 9.316071428571429e-09 0.03333333333333333 \
 9.317071428571428e-09 -0.03333333333333333 \
 9.325000000000001e-09 -0.03333333333333333 \
 9.326e-09 0.03333333333333333 \
 9.333928571428571e-09 0.03333333333333333 \
 9.33492857142857e-09 -0.1 \
 9.342857142857143e-09 -0.1 \
 9.343857142857142e-09 -0.03333333333333333 \
 9.351785714285715e-09 -0.03333333333333333 \
 9.352785714285714e-09 0.1 \
 9.360714285714285e-09 0.1 \
 9.361714285714284e-09 -0.1 \
 9.369642857142857e-09 -0.1 \
 9.370642857142856e-09 0.1 \
 9.378571428571429e-09 0.1 \
 9.379571428571428e-09 -0.03333333333333333 \
 9.387500000000001e-09 -0.03333333333333333 \
 9.3885e-09 -0.03333333333333333 \
 9.396428571428571e-09 -0.03333333333333333 \
 9.39742857142857e-09 0.1 \
 9.405357142857143e-09 0.1 \
 9.406357142857142e-09 -0.03333333333333333 \
 9.414285714285714e-09 -0.03333333333333333 \
 9.415285714285714e-09 -0.03333333333333333 \
 9.423214285714286e-09 -0.03333333333333333 \
 9.424214285714286e-09 0.03333333333333333 \
 9.432142857142857e-09 0.03333333333333333 \
 9.433142857142856e-09 0.03333333333333333 \
 9.441071428571428e-09 0.03333333333333333 \
 9.442071428571428e-09 0.1 \
 9.45e-09 0.1 \
 9.451e-09 -0.1 \
 9.458928571428572e-09 -0.1 \
 9.459928571428572e-09 0.03333333333333333 \
 9.467857142857142e-09 0.03333333333333333 \
 9.468857142857142e-09 -0.03333333333333333 \
 9.476785714285714e-09 -0.03333333333333333 \
 9.477785714285714e-09 0.03333333333333333 \
 9.485714285714286e-09 0.03333333333333333 \
 9.486714285714286e-09 0.1 \
 9.494642857142858e-09 0.1 \
 9.495642857142857e-09 0.1 \
 9.503571428571428e-09 0.1 \
 9.504571428571428e-09 -0.1 \
 9.5125e-09 -0.1 \
 9.513499999999999e-09 -0.1 \
 9.521428571428572e-09 -0.1 \
 9.522428571428571e-09 0.03333333333333333 \
 9.530357142857142e-09 0.03333333333333333 \
 9.531357142857142e-09 0.1 \
 9.539285714285714e-09 0.1 \
 9.540285714285713e-09 -0.03333333333333333 \
 9.548214285714286e-09 -0.03333333333333333 \
 9.549214285714285e-09 0.1 \
 9.557142857142858e-09 0.1 \
 9.558142857142857e-09 -0.03333333333333333 \
 9.566071428571428e-09 -0.03333333333333333 \
 9.567071428571427e-09 0.03333333333333333 \
 9.575e-09 0.03333333333333333 \
 9.575999999999999e-09 -0.03333333333333333 \
 9.583928571428572e-09 -0.03333333333333333 \
 9.584928571428571e-09 0.03333333333333333 \
 9.592857142857143e-09 0.03333333333333333 \
 9.593857142857143e-09 -0.1 \
 9.601785714285714e-09 -0.1 \
 9.602785714285713e-09 0.1 \
 9.610714285714286e-09 0.1 \
 9.611714285714285e-09 -0.03333333333333333 \
 9.619642857142857e-09 -0.03333333333333333 \
 9.620642857142857e-09 0.03333333333333333 \
 9.628571428571429e-09 0.03333333333333333 \
 9.629571428571429e-09 0.1 \
 9.637499999999999e-09 0.1 \
 9.638499999999999e-09 0.1 \
 9.646428571428571e-09 0.1 \
 9.647428571428571e-09 0.03333333333333333 \
 9.655357142857143e-09 0.03333333333333333 \
 9.656357142857143e-09 -0.03333333333333333 \
 9.664285714285715e-09 -0.03333333333333333 \
 9.665285714285715e-09 -0.1 \
 9.673214285714285e-09 -0.1 \
 9.674214285714285e-09 0.1 \
 9.682142857142857e-09 0.1 \
 9.683142857142857e-09 0.1 \
 9.691071428571429e-09 0.1 \
 9.692071428571428e-09 0.1 \
 9.699999999999999e-09 0.1 \
 9.700999999999999e-09 -0.1 \
 9.708928571428571e-09 -0.1 \
 9.709928571428571e-09 0.1 \
 9.717857142857143e-09 0.1 \
 9.718857142857142e-09 0.1 \
 9.726785714285715e-09 0.1 \
 9.727785714285714e-09 -0.1 \
 9.735714285714285e-09 -0.1 \
 9.736714285714284e-09 -0.03333333333333333 \
 9.744642857142857e-09 -0.03333333333333333 \
 9.745642857142856e-09 -0.03333333333333333 \
 9.753571428571429e-09 -0.03333333333333333 \
 9.754571428571428e-09 0.1 \
 9.762500000000001e-09 0.1 \
 9.7635e-09 0.1 \
 9.771428571428571e-09 0.1 \
 9.77242857142857e-09 0.1 \
 9.780357142857143e-09 0.1 \
 9.781357142857142e-09 0.03333333333333333 \
 9.789285714285714e-09 0.03333333333333333 \
 9.790285714285714e-09 -0.03333333333333333 \
 9.798214285714286e-09 -0.03333333333333333 \
 9.799214285714286e-09 0.1 \
 9.807142857142857e-09 0.1 \
 9.808142857142856e-09 0.1 \
 9.816071428571428e-09 0.1 \
 9.817071428571428e-09 0.1 \
 9.825e-09 0.1 \
 9.826e-09 -0.1 \
 9.833928571428572e-09 -0.1 \
 9.834928571428572e-09 -0.03333333333333333 \
 9.842857142857142e-09 -0.03333333333333333 \
 9.843857142857142e-09 -0.1 \
 9.851785714285714e-09 -0.1 \
 9.852785714285714e-09 0.03333333333333333 \
 9.860714285714286e-09 0.03333333333333333 \
 9.861714285714286e-09 0.03333333333333333 \
 9.869642857142858e-09 0.03333333333333333 \
 9.870642857142857e-09 -0.1 \
 9.878571428571428e-09 -0.1 \
 9.879571428571428e-09 0.03333333333333333 \
 9.8875e-09 0.03333333333333333 \
 9.8885e-09 -0.03333333333333333 \
 9.896428571428572e-09 -0.03333333333333333 \
 9.897428571428571e-09 -0.03333333333333333 \
 9.905357142857142e-09 -0.03333333333333333 \
 9.906357142857142e-09 -0.03333333333333333 \
 9.914285714285714e-09 -0.03333333333333333 \
 9.915285714285713e-09 -0.03333333333333333 \
 9.923214285714286e-09 -0.03333333333333333 \
 9.924214285714285e-09 0.03333333333333333 \
 9.932142857142858e-09 0.03333333333333333 \
 9.933142857142857e-09 -0.03333333333333333 \
 9.941071428571428e-09 -0.03333333333333333 \
 9.942071428571427e-09 -0.03333333333333333 \
 9.95e-09 -0.03333333333333333 \
 9.950999999999999e-09 -0.1 \
 9.958928571428572e-09 -0.1 \
 9.959928571428571e-09 -0.1 \
 9.967857142857143e-09 -0.1 \
 9.968857142857143e-09 -0.1 \
 9.976785714285714e-09 -0.1 \
 9.977785714285713e-09 -0.03333333333333333 \
 9.985714285714286e-09 -0.03333333333333333 \
 9.986714285714285e-09 -0.1 \
 9.994642857142857e-09 -0.1 \
 9.995642857142857e-09 0.1 \
 1.000357142857143e-08 0.1 \
 1.000457142857143e-08 -0.1 \
 1.00125e-08 -0.1 \
 1.00135e-08 0.03333333333333333 \
 1.002142857142857e-08 0.03333333333333333 \
 1.002242857142857e-08 0.03333333333333333 \
 1.003035714285714e-08 0.03333333333333333 \
 1.003135714285714e-08 0.03333333333333333 \
 1.003928571428572e-08 0.03333333333333333 \
 1.004028571428571e-08 -0.1 \
 1.004821428571429e-08 -0.1 \
 1.004921428571428e-08 0.1 \
 1.005714285714286e-08 0.1 \
 1.005814285714286e-08 -0.1 \
 1.006607142857143e-08 -0.1 \
 1.006707142857143e-08 0.1 \
 1.0075e-08 0.1 \
 1.0076e-08 -0.1 \
 1.008392857142857e-08 -0.1 \
 1.008492857142857e-08 -0.03333333333333333 \
 1.009285714285714e-08 -0.03333333333333333 \
 1.009385714285714e-08 -0.03333333333333333 \
 1.010178571428571e-08 -0.03333333333333333 \
 1.010278571428571e-08 0.03333333333333333 \
 1.011071428571429e-08 0.03333333333333333 \
 1.011171428571428e-08 -0.1 \
 1.011964285714286e-08 -0.1 \
 1.012064285714286e-08 -0.1 \
 1.012857142857143e-08 -0.1 \
 1.012957142857143e-08 0.03333333333333333 \
 1.01375e-08 0.03333333333333333 \
 1.01385e-08 -0.03333333333333333 \
 1.014642857142857e-08 -0.03333333333333333 \
 1.014742857142857e-08 -0.1 \
 1.015535714285714e-08 -0.1 \
 1.015635714285714e-08 0.03333333333333333 \
 1.016428571428571e-08 0.03333333333333333 \
 1.016528571428571e-08 0.03333333333333333 \
 1.017321428571429e-08 0.03333333333333333 \
 1.017421428571429e-08 0.03333333333333333 \
 1.018214285714286e-08 0.03333333333333333 \
 1.018314285714286e-08 0.1 \
 1.019107142857143e-08 0.1 \
 1.019207142857143e-08 0.1 \
 1.02e-08 0.1 \
 1.0201e-08 -0.03333333333333333 \
 1.020892857142857e-08 -0.03333333333333333 \
 1.020992857142857e-08 -0.03333333333333333 \
 1.021785714285714e-08 -0.03333333333333333 \
 1.021885714285714e-08 -0.03333333333333333 \
 1.022678571428571e-08 -0.03333333333333333 \
 1.022778571428571e-08 -0.03333333333333333 \
 1.023571428571429e-08 -0.03333333333333333 \
 1.023671428571429e-08 -0.03333333333333333 \
 1.024464285714286e-08 -0.03333333333333333 \
 1.024564285714286e-08 -0.1 \
 1.025357142857143e-08 -0.1 \
 1.025457142857143e-08 -0.03333333333333333 \
 1.02625e-08 -0.03333333333333333 \
 1.02635e-08 -0.1 \
 1.027142857142857e-08 -0.1 \
 1.027242857142857e-08 0.1 \
 1.028035714285714e-08 0.1 \
 1.028135714285714e-08 0.1 \
 1.028928571428571e-08 0.1 \
 1.029028571428571e-08 0.1 \
 1.029821428571429e-08 0.1 \
 1.029921428571429e-08 0.03333333333333333 \
 1.030714285714286e-08 0.03333333333333333 \
 1.030814285714286e-08 0.03333333333333333 \
 1.031607142857143e-08 0.03333333333333333 \
 1.031707142857143e-08 -0.1 \
 1.0325e-08 -0.1 \
 1.0326e-08 0.1 \
 1.033392857142857e-08 0.1 \
 1.033492857142857e-08 -0.1 \
 1.034285714285714e-08 -0.1 \
 1.034385714285714e-08 -0.03333333333333333 \
 1.035178571428571e-08 -0.03333333333333333 \
 1.035278571428571e-08 0.03333333333333333 \
 1.036071428571429e-08 0.03333333333333333 \
 1.036171428571429e-08 -0.03333333333333333 \
 1.036964285714286e-08 -0.03333333333333333 \
 1.037064285714286e-08 -0.03333333333333333 \
 1.037857142857143e-08 -0.03333333333333333 \
 1.037957142857143e-08 -0.03333333333333333 \
 1.03875e-08 -0.03333333333333333 \
 1.03885e-08 -0.03333333333333333 \
 1.039642857142857e-08 -0.03333333333333333 \
 1.039742857142857e-08 0.1 \
 1.040535714285714e-08 0.1 \
 1.040635714285714e-08 0.1 \
 1.041428571428571e-08 0.1 \
 1.041528571428571e-08 0.1 \
 1.042321428571429e-08 0.1 \
 1.042421428571428e-08 0.1 \
 1.043214285714286e-08 0.1 \
 1.043314285714286e-08 0.03333333333333333 \
 1.044107142857143e-08 0.03333333333333333 \
 1.044207142857143e-08 -0.03333333333333333 \
 1.045e-08 -0.03333333333333333 \
 1.0451e-08 0.1 \
 1.045892857142857e-08 0.1 \
 1.045992857142857e-08 0.03333333333333333 \
 1.046785714285714e-08 0.03333333333333333 \
 1.046885714285714e-08 -0.1 \
 1.047678571428571e-08 -0.1 \
 1.047778571428571e-08 -0.03333333333333333 \
 1.048571428571429e-08 -0.03333333333333333 \
 1.048671428571428e-08 0.03333333333333333 \
 1.049464285714286e-08 0.03333333333333333 \
 1.049564285714286e-08 0.03333333333333333 \
 1.050357142857143e-08 0.03333333333333333 \
 1.050457142857143e-08 -0.03333333333333333 \
 1.05125e-08 -0.03333333333333333 \
 1.05135e-08 0.1 \
 1.052142857142857e-08 0.1 \
 1.052242857142857e-08 -0.1 \
 1.053035714285714e-08 -0.1 \
 1.053135714285714e-08 -0.03333333333333333 \
 1.053928571428571e-08 -0.03333333333333333 \
 1.054028571428571e-08 0.03333333333333333 \
 1.054821428571429e-08 0.03333333333333333 \
 1.054921428571429e-08 -0.1 \
 1.055714285714286e-08 -0.1 \
 1.055814285714286e-08 -0.03333333333333333 \
 1.056607142857143e-08 -0.03333333333333333 \
 1.056707142857143e-08 -0.1 \
 1.0575e-08 -0.1 \
 1.0576e-08 -0.1 \
 1.058392857142857e-08 -0.1 \
 1.058492857142857e-08 0.1 \
 1.059285714285714e-08 0.1 \
 1.059385714285714e-08 0.03333333333333333 \
 1.060178571428571e-08 0.03333333333333333 \
 1.060278571428571e-08 -0.1 \
 1.061071428571429e-08 -0.1 \
 1.061171428571429e-08 -0.1 \
 1.061964285714286e-08 -0.1 \
 1.062064285714286e-08 -0.1 \
 1.062857142857143e-08 -0.1 \
 1.062957142857143e-08 -0.03333333333333333 \
 1.06375e-08 -0.03333333333333333 \
 1.06385e-08 0.03333333333333333 \
 1.064642857142857e-08 0.03333333333333333 \
 1.064742857142857e-08 0.1 \
 1.065535714285714e-08 0.1 \
 1.065635714285714e-08 0.1 \
 1.066428571428571e-08 0.1 \
 1.066528571428571e-08 -0.03333333333333333 \
 1.067321428571429e-08 -0.03333333333333333 \
 1.067421428571429e-08 -0.03333333333333333 \
 1.068214285714286e-08 -0.03333333333333333 \
 1.068314285714286e-08 0.03333333333333333 \
 1.069107142857143e-08 0.03333333333333333 \
 1.069207142857143e-08 -0.03333333333333333 \
 1.07e-08 -0.03333333333333333 \
 1.0701e-08 0.03333333333333333 \
 1.070892857142857e-08 0.03333333333333333 \
 1.070992857142857e-08 -0.03333333333333333 \
 1.071785714285714e-08 -0.03333333333333333 \
 1.071885714285714e-08 -0.1 \
 1.072678571428571e-08 -0.1 \
 1.072778571428571e-08 -0.1 \
 1.073571428571429e-08 -0.1 \
 1.073671428571429e-08 0.1 \
 1.074464285714286e-08 0.1 \
 1.074564285714286e-08 0.03333333333333333 \
 1.075357142857143e-08 0.03333333333333333 \
 1.075457142857143e-08 0.03333333333333333 \
 1.07625e-08 0.03333333333333333 \
 1.07635e-08 0.1 \
 1.077142857142857e-08 0.1 \
 1.077242857142857e-08 -0.03333333333333333 \
 1.078035714285714e-08 -0.03333333333333333 \
 1.078135714285714e-08 -0.03333333333333333 \
 1.078928571428571e-08 -0.03333333333333333 \
 1.079028571428571e-08 -0.1 \
 1.079821428571429e-08 -0.1 \
 1.079921428571428e-08 0.1 \
 1.080714285714286e-08 0.1 \
 1.080814285714286e-08 0.03333333333333333 \
 1.081607142857143e-08 0.03333333333333333 \
 1.081707142857143e-08 0.1 \
 1.0825e-08 0.1 \
 1.0826e-08 0.1 \
 1.083392857142857e-08 0.1 \
 1.083492857142857e-08 -0.1 \
 1.084285714285714e-08 -0.1 \
 1.084385714285714e-08 0.03333333333333333 \
 1.085178571428571e-08 0.03333333333333333 \
 1.085278571428571e-08 -0.03333333333333333 \
 1.086071428571429e-08 -0.03333333333333333 \
 1.086171428571428e-08 0.03333333333333333 \
 1.086964285714286e-08 0.03333333333333333 \
 1.087064285714286e-08 -0.03333333333333333 \
 1.087857142857143e-08 -0.03333333333333333 \
 1.087957142857143e-08 0.1 \
 1.08875e-08 0.1 \
 1.08885e-08 -0.1 \
 1.089642857142857e-08 -0.1 \
 1.089742857142857e-08 0.1 \
 1.090535714285714e-08 0.1 \
 1.090635714285714e-08 -0.1 \
 1.091428571428571e-08 -0.1 \
 1.091528571428571e-08 0.03333333333333333 \
 1.092321428571429e-08 0.03333333333333333 \
 1.092421428571429e-08 -0.1 \
 1.093214285714286e-08 -0.1 \
 1.093314285714286e-08 0.1 \
 1.094107142857143e-08 0.1 \
 1.094207142857143e-08 0.03333333333333333 \
 1.095e-08 0.03333333333333333 \
 1.0951e-08 0.03333333333333333 \
 1.095892857142857e-08 0.03333333333333333 \
 1.095992857142857e-08 0.1 \
 1.096785714285714e-08 0.1 \
 1.096885714285714e-08 -0.03333333333333333 \
 1.097678571428571e-08 -0.03333333333333333 \
 1.097778571428571e-08 -0.03333333333333333 \
 1.098571428571429e-08 -0.03333333333333333 \
 1.098671428571429e-08 0.1 \
 1.099464285714286e-08 0.1 \
 1.099564285714286e-08 -0.03333333333333333 \
 1.100357142857143e-08 -0.03333333333333333 \
 1.100457142857143e-08 0.1 \
 1.10125e-08 0.1 \
 1.10135e-08 0.1 \
 1.102142857142857e-08 0.1 \
 1.102242857142857e-08 -0.03333333333333333 \
 1.103035714285714e-08 -0.03333333333333333 \
 1.103135714285714e-08 0.1 \
 1.103928571428571e-08 0.1 \
 1.104028571428571e-08 -0.03333333333333333 \
 1.104821428571429e-08 -0.03333333333333333 \
 1.104921428571429e-08 -0.03333333333333333 \
 1.105714285714286e-08 -0.03333333333333333 \
 1.105814285714286e-08 -0.1 \
 1.106607142857143e-08 -0.1 \
 1.106707142857143e-08 -0.1 \
 1.1075e-08 -0.1 \
 1.1076e-08 -0.1 \
 1.108392857142857e-08 -0.1 \
 1.108492857142857e-08 -0.1 \
 1.109285714285714e-08 -0.1 \
 1.109385714285714e-08 0.1 \
 1.110178571428571e-08 0.1 \
 1.110278571428571e-08 -0.1 \
 1.111071428571429e-08 -0.1 \
 1.111171428571429e-08 0.03333333333333333 \
 1.111964285714286e-08 0.03333333333333333 \
 1.112064285714286e-08 0.03333333333333333 \
 1.112857142857143e-08 0.03333333333333333 \
 1.112957142857143e-08 -0.03333333333333333 \
 1.11375e-08 -0.03333333333333333 \
 1.11385e-08 -0.1 \
 1.114642857142857e-08 -0.1 \
 1.114742857142857e-08 0.03333333333333333 \
 1.115535714285714e-08 0.03333333333333333 \
 1.115635714285714e-08 -0.03333333333333333 \
 1.116428571428571e-08 -0.03333333333333333 \
 1.116528571428571e-08 0.03333333333333333 \
 1.117321428571429e-08 0.03333333333333333 \
 1.117421428571428e-08 0.1 \
 1.118214285714286e-08 0.1 \
 1.118314285714286e-08 0.03333333333333333 \
 1.119107142857143e-08 0.03333333333333333 \
 1.119207142857143e-08 0.1 \
 1.12e-08 0.1 \
 1.1201e-08 0.1 \
 1.120892857142857e-08 0.1 \
 1.120992857142857e-08 -0.1 \
 1.121785714285714e-08 -0.1 \
 1.121885714285714e-08 0.1 \
 1.122678571428571e-08 0.1 \
 1.122778571428571e-08 0.1 \
 1.123571428571429e-08 0.1 \
 1.123671428571428e-08 0.1 \
 1.124464285714286e-08 0.1 \
 1.124564285714286e-08 0.1 \
 1.125357142857143e-08 0.1 \
 1.125457142857143e-08 0.1 \
 1.12625e-08 0.1 \
 1.12635e-08 0.03333333333333333 \
 1.127142857142857e-08 0.03333333333333333 \
 1.127242857142857e-08 -0.03333333333333333 \
 1.128035714285714e-08 -0.03333333333333333 \
 1.128135714285714e-08 0.1 \
 1.128928571428571e-08 0.1 \
 1.129028571428571e-08 0.03333333333333333 \
 1.129821428571428e-08 0.03333333333333333 \
 1.129921428571428e-08 0.03333333333333333 \
 1.130714285714286e-08 0.03333333333333333 \
 1.130814285714286e-08 0.1 \
 1.131607142857143e-08 0.1 \
 1.131707142857143e-08 -0.03333333333333333 \
 1.1325e-08 -0.03333333333333333 \
 1.1326e-08 0.1 \
 1.133392857142857e-08 0.1 \
 1.133492857142857e-08 0.03333333333333333 \
 1.134285714285714e-08 0.03333333333333333 \
 1.134385714285714e-08 -0.1 \
 1.135178571428571e-08 -0.1 \
 1.135278571428571e-08 -0.1 \
 1.136071428571429e-08 -0.1 \
 1.136171428571429e-08 -0.1 \
 1.136964285714286e-08 -0.1 \
 1.137064285714286e-08 0.1 \
 1.137857142857143e-08 0.1 \
 1.137957142857143e-08 -0.1 \
 1.13875e-08 -0.1 \
 1.13885e-08 0.1 \
 1.139642857142857e-08 0.1 \
 1.139742857142857e-08 0.03333333333333333 \
 1.140535714285714e-08 0.03333333333333333 \
 1.140635714285714e-08 0.1 \
 1.141428571428571e-08 0.1 \
 1.141528571428571e-08 -0.03333333333333333 \
 1.142321428571429e-08 -0.03333333333333333 \
 1.142421428571429e-08 -0.03333333333333333 \
 1.143214285714286e-08 -0.03333333333333333 \
 1.143314285714286e-08 -0.03333333333333333 \
 1.144107142857143e-08 -0.03333333333333333 \
 1.144207142857143e-08 -0.03333333333333333 \
 1.145e-08 -0.03333333333333333 \
 1.1451e-08 -0.1 \
 1.145892857142857e-08 -0.1 \
 1.145992857142857e-08 0.1 \
 1.146785714285714e-08 0.1 \
 1.146885714285714e-08 -0.1 \
 1.147678571428571e-08 -0.1 \
 1.147778571428571e-08 -0.1 \
 1.148571428571429e-08 -0.1 \
 1.148671428571429e-08 -0.1 \
 1.149464285714286e-08 -0.1 \
 1.149564285714286e-08 -0.1 \
 1.150357142857143e-08 -0.1 \
 1.150457142857143e-08 -0.1 \
 1.15125e-08 -0.1 \
 1.15135e-08 -0.1 \
 1.152142857142857e-08 -0.1 \
 1.152242857142857e-08 -0.1 \
 1.153035714285714e-08 -0.1 \
 1.153135714285714e-08 -0.1 \
 1.153928571428571e-08 -0.1 \
 1.154028571428571e-08 -0.03333333333333333 \
 1.154821428571429e-08 -0.03333333333333333 \
 1.154921428571428e-08 0.03333333333333333 \
 1.155714285714286e-08 0.03333333333333333 \
 1.155814285714286e-08 -0.1 \
 1.156607142857143e-08 -0.1 \
 1.156707142857143e-08 -0.03333333333333333 \
 1.1575e-08 -0.03333333333333333 \
 1.1576e-08 -0.03333333333333333 \
 1.158392857142857e-08 -0.03333333333333333 \
 1.158492857142857e-08 -0.03333333333333333 \
 1.159285714285714e-08 -0.03333333333333333 \
 1.159385714285714e-08 0.1 \
 1.160178571428572e-08 0.1 \
 1.160278571428571e-08 -0.1 \
 1.161071428571429e-08 -0.1 \
 1.161171428571428e-08 0.03333333333333333 \
 1.161964285714286e-08 0.03333333333333333 \
 1.162064285714286e-08 -0.03333333333333333 \
 1.162857142857143e-08 -0.03333333333333333 \
 1.162957142857143e-08 0.1 \
 1.16375e-08 0.1 \
 1.16385e-08 0.1 \
 1.164642857142857e-08 0.1 \
 1.164742857142857e-08 -0.03333333333333333 \
 1.165535714285714e-08 -0.03333333333333333 \
 1.165635714285714e-08 0.03333333333333333 \
 1.166428571428571e-08 0.03333333333333333 \
 1.166528571428571e-08 0.03333333333333333 \
 1.167321428571428e-08 0.03333333333333333 \
 1.167421428571428e-08 -0.03333333333333333 \
 1.168214285714286e-08 -0.03333333333333333 \
 1.168314285714286e-08 0.1 \
 1.169107142857143e-08 0.1 \
 1.169207142857143e-08 0.03333333333333333 \
 1.17e-08 0.03333333333333333 \
 1.1701e-08 0.03333333333333333 \
 1.170892857142857e-08 0.03333333333333333 \
 1.170992857142857e-08 -0.03333333333333333 \
 1.171785714285714e-08 -0.03333333333333333 \
 1.171885714285714e-08 0.03333333333333333 \
 1.172678571428571e-08 0.03333333333333333 \
 1.172778571428571e-08 0.03333333333333333 \
 1.173571428571429e-08 0.03333333333333333 \
 1.173671428571429e-08 0.03333333333333333 \
 1.174464285714286e-08 0.03333333333333333 \
 1.174564285714286e-08 -0.1 \
 1.175357142857143e-08 -0.1 \
 1.175457142857143e-08 0.03333333333333333 \
 1.17625e-08 0.03333333333333333 \
 1.17635e-08 -0.03333333333333333 \
 1.177142857142857e-08 -0.03333333333333333 \
 1.177242857142857e-08 -0.1 \
 1.178035714285714e-08 -0.1 \
 1.178135714285714e-08 0.03333333333333333 \
 1.178928571428571e-08 0.03333333333333333 \
 1.179028571428571e-08 -0.1 \
 1.179821428571429e-08 -0.1 \
 1.179921428571429e-08 -0.03333333333333333 \
 1.180714285714286e-08 -0.03333333333333333 \
 1.180814285714286e-08 0.03333333333333333 \
 1.181607142857143e-08 0.03333333333333333 \
 1.181707142857143e-08 -0.03333333333333333 \
 1.1825e-08 -0.03333333333333333 \
 1.1826e-08 0.03333333333333333 \
 1.183392857142857e-08 0.03333333333333333 \
 1.183492857142857e-08 -0.03333333333333333 \
 1.184285714285714e-08 -0.03333333333333333 \
 1.184385714285714e-08 0.1 \
 1.185178571428571e-08 0.1 \
 1.185278571428571e-08 -0.03333333333333333 \
 1.186071428571429e-08 -0.03333333333333333 \
 1.186171428571429e-08 0.03333333333333333 \
 1.186964285714286e-08 0.03333333333333333 \
 1.187064285714286e-08 -0.03333333333333333 \
 1.187857142857143e-08 -0.03333333333333333 \
 1.187957142857143e-08 -0.03333333333333333 \
 1.18875e-08 -0.03333333333333333 \
 1.18885e-08 -0.1 \
 1.189642857142857e-08 -0.1 \
 1.189742857142857e-08 -0.1 \
 1.190535714285714e-08 -0.1 \
 1.190635714285714e-08 -0.03333333333333333 \
 1.191428571428571e-08 -0.03333333333333333 \
 1.191528571428571e-08 -0.03333333333333333 \
 1.192321428571429e-08 -0.03333333333333333 \
 1.192421428571429e-08 -0.03333333333333333 \
 1.193214285714286e-08 -0.03333333333333333 \
 1.193314285714286e-08 0.03333333333333333 \
 1.194107142857143e-08 0.03333333333333333 \
 1.194207142857143e-08 -0.1 \
 1.195e-08 -0.1 \
 1.1951e-08 -0.1 \
 1.195892857142857e-08 -0.1 \
 1.195992857142857e-08 0.03333333333333333 \
 1.196785714285714e-08 0.03333333333333333 \
 1.196885714285714e-08 -0.1 \
 1.197678571428572e-08 -0.1 \
 1.197778571428571e-08 -0.03333333333333333 \
 1.198571428571429e-08 -0.03333333333333333 \
 1.198671428571428e-08 -0.03333333333333333 \
 1.199464285714286e-08 -0.03333333333333333 \
 1.199564285714286e-08 0.03333333333333333 \
 1.200357142857143e-08 0.03333333333333333 \
 1.200457142857143e-08 0.03333333333333333 \
 1.20125e-08 0.03333333333333333 \
 1.20135e-08 0.03333333333333333 \
 1.202142857142857e-08 0.03333333333333333 \
 1.202242857142857e-08 -0.1 \
 1.203035714285714e-08 -0.1 \
 1.203135714285714e-08 -0.1 \
 1.203928571428571e-08 -0.1 \
 1.204028571428571e-08 0.03333333333333333 \
 1.204821428571429e-08 0.03333333333333333 \
 1.204921428571428e-08 0.1 \
 1.205714285714286e-08 0.1 \
 1.205814285714286e-08 0.03333333333333333 \
 1.206607142857143e-08 0.03333333333333333 \
 1.206707142857143e-08 -0.03333333333333333 \
 1.2075e-08 -0.03333333333333333 \
 1.2076e-08 -0.03333333333333333 \
 1.208392857142857e-08 -0.03333333333333333 \
 1.208492857142857e-08 -0.03333333333333333 \
 1.209285714285714e-08 -0.03333333333333333 \
 1.209385714285714e-08 0.03333333333333333 \
 1.210178571428571e-08 0.03333333333333333 \
 1.210278571428571e-08 -0.1 \
 1.211071428571429e-08 -0.1 \
 1.211171428571429e-08 0.03333333333333333 \
 1.211964285714286e-08 0.03333333333333333 \
 1.212064285714286e-08 -0.1 \
 1.212857142857143e-08 -0.1 \
 1.212957142857143e-08 0.03333333333333333 \
 1.21375e-08 0.03333333333333333 \
 1.21385e-08 -0.03333333333333333 \
 1.214642857142857e-08 -0.03333333333333333 \
 1.214742857142857e-08 0.1 \
 1.215535714285714e-08 0.1 \
 1.215635714285714e-08 0.1 \
 1.216428571428571e-08 0.1 \
 1.216528571428571e-08 0.1 \
 1.217321428571429e-08 0.1 \
 1.217421428571429e-08 -0.1 \
 1.218214285714286e-08 -0.1 \
 1.218314285714286e-08 0.1 \
 1.219107142857143e-08 0.1 \
 1.219207142857143e-08 -0.03333333333333333 \
 1.22e-08 -0.03333333333333333 \
 1.2201e-08 0.1 \
 1.220892857142857e-08 0.1 \
 1.220992857142857e-08 -0.1 \
 1.221785714285714e-08 -0.1 \
 1.221885714285714e-08 -0.1 \
 1.222678571428571e-08 -0.1 \
 1.222778571428571e-08 -0.03333333333333333 \
 1.223571428571429e-08 -0.03333333333333333 \
 1.223671428571429e-08 -0.03333333333333333 \
 1.224464285714286e-08 -0.03333333333333333 \
 1.224564285714286e-08 0.03333333333333333 \
 1.225357142857143e-08 0.03333333333333333 \
 1.225457142857143e-08 -0.03333333333333333 \
 1.22625e-08 -0.03333333333333333 \
 1.22635e-08 -0.03333333333333333 \
 1.227142857142857e-08 -0.03333333333333333 \
 1.227242857142857e-08 0.1 \
 1.228035714285714e-08 0.1 \
 1.228135714285714e-08 0.1 \
 1.228928571428571e-08 0.1 \
 1.229028571428571e-08 -0.1 \
 1.229821428571429e-08 -0.1 \
 1.229921428571429e-08 -0.03333333333333333 \
 1.230714285714286e-08 -0.03333333333333333 \
 1.230814285714286e-08 0.03333333333333333 \
 1.231607142857143e-08 0.03333333333333333 \
 1.231707142857143e-08 0.1 \
 1.2325e-08 0.1 \
 1.2326e-08 0.03333333333333333 \
 1.233392857142857e-08 0.03333333333333333 \
 1.233492857142857e-08 0.03333333333333333 \
 1.234285714285714e-08 0.03333333333333333 \
 1.234385714285714e-08 -0.1 \
 1.235178571428571e-08 -0.1 \
 1.235278571428571e-08 0.03333333333333333 \
 1.236071428571429e-08 0.03333333333333333 \
 1.236171428571428e-08 -0.03333333333333333 \
 1.236964285714286e-08 -0.03333333333333333 \
 1.237064285714286e-08 -0.03333333333333333 \
 1.237857142857143e-08 -0.03333333333333333 \
 1.237957142857143e-08 -0.1 \
 1.23875e-08 -0.1 \
 1.23885e-08 0.03333333333333333 \
 1.239642857142857e-08 0.03333333333333333 \
 1.239742857142857e-08 -0.1 \
 1.240535714285714e-08 -0.1 \
 1.240635714285714e-08 -0.1 \
 1.241428571428571e-08 -0.1 \
 1.241528571428571e-08 -0.1 \
 1.242321428571429e-08 -0.1 \
 1.242421428571428e-08 -0.03333333333333333 \
 1.243214285714286e-08 -0.03333333333333333 \
 1.243314285714286e-08 -0.1 \
 1.244107142857143e-08 -0.1 \
 1.244207142857143e-08 -0.1 \
 1.245e-08 -0.1 \
 1.2451e-08 -0.1 \
 1.245892857142857e-08 -0.1 \
 1.245992857142857e-08 -0.03333333333333333 \
 1.246785714285714e-08 -0.03333333333333333 \
 1.246885714285714e-08 0.1 \
 1.247678571428571e-08 0.1 \
 1.247778571428571e-08 0.1 \
 1.248571428571429e-08 0.1 \
 1.248671428571429e-08 0.03333333333333333 \
 1.249464285714286e-08 0.03333333333333333 \
 1.249564285714286e-08 0.1 \
 1.250357142857143e-08 0.1 \
 1.250457142857143e-08 -0.03333333333333333 \
 1.25125e-08 -0.03333333333333333 \
 1.25135e-08 0.03333333333333333 \
 1.252142857142857e-08 0.03333333333333333 \
 1.252242857142857e-08 0.03333333333333333 \
 1.253035714285714e-08 0.03333333333333333 \
 1.253135714285714e-08 0.1 \
 1.253928571428571e-08 0.1 \
 1.254028571428571e-08 0.1 \
 1.254821428571429e-08 0.1 \
 1.254921428571429e-08 -0.03333333333333333 \
 1.255714285714286e-08 -0.03333333333333333 \
 1.255814285714286e-08 -0.03333333333333333 \
 1.256607142857143e-08 -0.03333333333333333 \
 1.256707142857143e-08 -0.03333333333333333 \
 1.2575e-08 -0.03333333333333333 \
 1.2576e-08 -0.1 \
 1.258392857142857e-08 -0.1 \
 1.258492857142857e-08 -0.1 \
 1.259285714285714e-08 -0.1 \
 1.259385714285714e-08 -0.1 \
 1.260178571428571e-08 -0.1 \
 1.260278571428571e-08 0.1 \
 1.261071428571429e-08 0.1 \
 1.261171428571429e-08 0.1 \
 1.261964285714286e-08 0.1 \
 1.262064285714286e-08 -0.03333333333333333 \
 1.262857142857143e-08 -0.03333333333333333 \
 1.262957142857143e-08 0.03333333333333333 \
 1.26375e-08 0.03333333333333333 \
 1.26385e-08 0.1 \
 1.264642857142857e-08 0.1 \
 1.264742857142857e-08 -0.03333333333333333 \
 1.265535714285714e-08 -0.03333333333333333 \
 1.265635714285714e-08 0.1 \
 1.266428571428571e-08 0.1 \
 1.266528571428571e-08 -0.1 \
 1.267321428571429e-08 -0.1 \
 1.267421428571429e-08 -0.1 \
 1.268214285714286e-08 -0.1 \
 1.268314285714286e-08 -0.03333333333333333 \
 1.269107142857143e-08 -0.03333333333333333 \
 1.269207142857143e-08 -0.1 \
 1.27e-08 -0.1 \
 1.2701e-08 -0.03333333333333333 \
 1.270892857142857e-08 -0.03333333333333333 \
 1.270992857142857e-08 -0.1 \
 1.271785714285714e-08 -0.1 \
 1.271885714285714e-08 -0.03333333333333333 \
 1.272678571428571e-08 -0.03333333333333333 \
 1.272778571428571e-08 0.03333333333333333 \
 1.273571428571429e-08 0.03333333333333333 \
 1.273671428571428e-08 -0.1 \
 1.274464285714286e-08 -0.1 \
 1.274564285714286e-08 0.1 \
 1.275357142857143e-08 0.1 \
 1.275457142857143e-08 0.03333333333333333 \
 1.27625e-08 0.03333333333333333 \
 1.27635e-08 0.1 \
 1.277142857142857e-08 0.1 \
 1.277242857142857e-08 0.1 \
 1.278035714285714e-08 0.1 \
 1.278135714285714e-08 0.1 \
 1.278928571428571e-08 0.1 \
 1.279028571428571e-08 -0.1 \
 1.279821428571429e-08 -0.1 \
 1.279921428571428e-08 -0.1 \
 1.280714285714286e-08 -0.1 \
 1.280814285714286e-08 -0.03333333333333333 \
 1.281607142857143e-08 -0.03333333333333333 \
 1.281707142857143e-08 -0.1 \
 1.2825e-08 -0.1 \
 1.2826e-08 0.03333333333333333 \
 1.283392857142857e-08 0.03333333333333333 \
 1.283492857142857e-08 0.1 \
 1.284285714285714e-08 0.1 \
 1.284385714285714e-08 -0.1 \
 1.285178571428571e-08 -0.1 \
 1.285278571428571e-08 -0.03333333333333333 \
 1.286071428571428e-08 -0.03333333333333333 \
 1.286171428571428e-08 -0.1 \
 1.286964285714286e-08 -0.1 \
 1.287064285714286e-08 -0.03333333333333333 \
 1.287857142857143e-08 -0.03333333333333333 \
 1.287957142857143e-08 0.03333333333333333 \
 1.28875e-08 0.03333333333333333 \
 1.28885e-08 0.1 \
 1.289642857142857e-08 0.1 \
 1.289742857142857e-08 0.1 \
 1.290535714285714e-08 0.1 \
 1.290635714285714e-08 -0.03333333333333333 \
 1.291428571428571e-08 -0.03333333333333333 \
 1.291528571428571e-08 0.03333333333333333 \
 1.292321428571429e-08 0.03333333333333333 \
 1.292421428571429e-08 -0.03333333333333333 \
 1.293214285714286e-08 -0.03333333333333333 \
 1.293314285714286e-08 -0.1 \
 1.294107142857143e-08 -0.1 \
 1.294207142857143e-08 -0.03333333333333333 \
 1.295e-08 -0.03333333333333333 \
 1.2951e-08 -0.1 \
 1.295892857142857e-08 -0.1 \
 1.295992857142857e-08 -0.03333333333333333 \
 1.296785714285714e-08 -0.03333333333333333 \
 1.296885714285714e-08 -0.03333333333333333 \
 1.297678571428571e-08 -0.03333333333333333 \
 1.297778571428571e-08 0.1 \
 1.298571428571429e-08 0.1 \
 1.298671428571429e-08 -0.03333333333333333 \
 1.299464285714286e-08 -0.03333333333333333 \
 1.299564285714286e-08 0.03333333333333333 \
 1.300357142857143e-08 0.03333333333333333 \
 1.300457142857143e-08 0.1 \
 1.30125e-08 0.1 \
 1.30135e-08 0.03333333333333333 \
 1.302142857142857e-08 0.03333333333333333 \
 1.302242857142857e-08 0.1 \
 1.303035714285714e-08 0.1 \
 1.303135714285714e-08 -0.1 \
 1.303928571428571e-08 -0.1 \
 1.304028571428571e-08 -0.03333333333333333 \
 1.304821428571429e-08 -0.03333333333333333 \
 1.304921428571429e-08 0.03333333333333333 \
 1.305714285714286e-08 0.03333333333333333 \
 1.305814285714286e-08 0.1 \
 1.306607142857143e-08 0.1 \
 1.306707142857143e-08 0.03333333333333333 \
 1.3075e-08 0.03333333333333333 \
 1.3076e-08 0.1 \
 1.308392857142857e-08 0.1 \
 1.308492857142857e-08 -0.03333333333333333 \
 1.309285714285714e-08 -0.03333333333333333 \
 1.309385714285714e-08 -0.03333333333333333 \
 1.310178571428571e-08 -0.03333333333333333 \
 1.310278571428571e-08 0.03333333333333333 \
 1.311071428571429e-08 0.03333333333333333 \
 1.311171428571428e-08 0.03333333333333333 \
 1.311964285714286e-08 0.03333333333333333 \
 1.312064285714286e-08 0.1 \
 1.312857142857143e-08 0.1 \
 1.312957142857143e-08 -0.1 \
 1.31375e-08 -0.1 \
 1.31385e-08 0.1 \
 1.314642857142857e-08 0.1 \
 1.314742857142857e-08 -0.03333333333333333 \
 1.315535714285714e-08 -0.03333333333333333 \
 1.315635714285714e-08 0.1 \
 1.316428571428571e-08 0.1 \
 1.316528571428571e-08 -0.1 \
 1.317321428571429e-08 -0.1 \
 1.317421428571428e-08 -0.03333333333333333 \
 1.318214285714286e-08 -0.03333333333333333 \
 1.318314285714286e-08 0.03333333333333333 \
 1.319107142857143e-08 0.03333333333333333 \
 1.319207142857143e-08 0.1 \
 1.32e-08 0.1 \
 1.3201e-08 0.03333333333333333 \
 1.320892857142857e-08 0.03333333333333333 \
 1.320992857142857e-08 0.1 \
 1.321785714285714e-08 0.1 \
 1.321885714285714e-08 -0.1 \
 1.322678571428571e-08 -0.1 \
 1.322778571428571e-08 -0.1 \
 1.323571428571428e-08 -0.1 \
 1.323671428571428e-08 -0.1 \
 1.324464285714286e-08 -0.1 \
 1.324564285714286e-08 -0.1 \
 1.325357142857143e-08 -0.1 \
 1.325457142857143e-08 -0.03333333333333333 \
 1.32625e-08 -0.03333333333333333 \
 1.32635e-08 -0.1 \
 1.327142857142857e-08 -0.1 \
 1.327242857142857e-08 -0.1 \
 1.328035714285714e-08 -0.1 \
 1.328135714285714e-08 0.03333333333333333 \
 1.328928571428571e-08 0.03333333333333333 \
 1.329028571428571e-08 0.1 \
 1.329821428571429e-08 0.1 \
 1.329921428571429e-08 0.1 \
 1.330714285714286e-08 0.1 \
 1.330814285714286e-08 0.1 \
 1.331607142857143e-08 0.1 \
 1.331707142857143e-08 0.03333333333333333 \
 1.3325e-08 0.03333333333333333 \
 1.3326e-08 -0.03333333333333333 \
 1.333392857142857e-08 -0.03333333333333333 \
 1.333492857142857e-08 0.03333333333333333 \
 1.334285714285714e-08 0.03333333333333333 \
 1.334385714285714e-08 0.03333333333333333 \
 1.335178571428571e-08 0.03333333333333333 \
 1.335278571428571e-08 -0.1 \
 1.336071428571429e-08 -0.1 \
 1.336171428571429e-08 -0.1 \
 1.336964285714286e-08 -0.1 \
 1.337064285714286e-08 0.1 \
 1.337857142857143e-08 0.1 \
 1.337957142857143e-08 0.1 \
 1.33875e-08 0.1 \
 1.33885e-08 0.1 \
 1.339642857142857e-08 0.1 \
 1.339742857142857e-08 -0.1 \
 1.340535714285714e-08 -0.1 \
 1.340635714285714e-08 0.1 \
 1.341428571428571e-08 0.1 \
 1.341528571428571e-08 -0.1 \
 1.342321428571429e-08 -0.1 \
 1.342421428571429e-08 -0.03333333333333333 \
 1.343214285714286e-08 -0.03333333333333333 \
 1.343314285714286e-08 -0.03333333333333333 \
 1.344107142857143e-08 -0.03333333333333333 \
 1.344207142857143e-08 -0.1 \
 1.345e-08 -0.1 \
 1.3451e-08 -0.1 \
 1.345892857142857e-08 -0.1 \
 1.345992857142857e-08 0.03333333333333333 \
 1.346785714285714e-08 0.03333333333333333 \
 1.346885714285714e-08 -0.1 \
 1.347678571428571e-08 -0.1 \
 1.347778571428571e-08 -0.1 \
 1.348571428571429e-08 -0.1 \
 1.348671428571428e-08 -0.03333333333333333 \
 1.349464285714286e-08 -0.03333333333333333 \
 1.349564285714286e-08 0.1 \
 1.350357142857143e-08 0.1 \
 1.350457142857143e-08 -0.03333333333333333 \
 1.35125e-08 -0.03333333333333333 \
 1.35135e-08 0.03333333333333333 \
 1.352142857142857e-08 0.03333333333333333 \
 1.352242857142857e-08 -0.03333333333333333 \
 1.353035714285714e-08 -0.03333333333333333 \
 1.353135714285714e-08 0.03333333333333333 \
 1.353928571428571e-08 0.03333333333333333 \
 1.354028571428571e-08 -0.1 \
 1.354821428571429e-08 -0.1 \
 1.354921428571428e-08 0.1 \
 1.355714285714286e-08 0.1 \
 1.355814285714286e-08 0.03333333333333333 \
 1.356607142857143e-08 0.03333333333333333 \
 1.356707142857143e-08 -0.03333333333333333 \
 1.3575e-08 -0.03333333333333333 \
 1.3576e-08 -0.1 \
 1.358392857142857e-08 -0.1 \
 1.358492857142857e-08 0.1 \
 1.359285714285714e-08 0.1 \
 1.359385714285714e-08 -0.1 \
 1.360178571428571e-08 -0.1 \
 1.360278571428571e-08 0.1 \
 1.361071428571428e-08 0.1 \
 1.361171428571428e-08 0.03333333333333333 \
 1.361964285714286e-08 0.03333333333333333 \
 1.362064285714286e-08 -0.1 \
 1.362857142857143e-08 -0.1 \
 1.362957142857143e-08 -0.1 \
 1.36375e-08 -0.1 \
 1.36385e-08 0.1 \
 1.364642857142857e-08 0.1 \
 1.364742857142857e-08 -0.1 \
 1.365535714285714e-08 -0.1 \
 1.365635714285714e-08 -0.03333333333333333 \
 1.366428571428571e-08 -0.03333333333333333 \
 1.366528571428571e-08 -0.03333333333333333 \
 1.367321428571429e-08 -0.03333333333333333 \
 1.367421428571429e-08 -0.03333333333333333 \
 1.368214285714286e-08 -0.03333333333333333 \
 1.368314285714286e-08 -0.1 \
 1.369107142857143e-08 -0.1 \
 1.369207142857143e-08 0.1 \
 1.37e-08 0.1 \
 1.3701e-08 -0.03333333333333333 \
 1.370892857142857e-08 -0.03333333333333333 \
 1.370992857142857e-08 -0.03333333333333333 \
 1.371785714285714e-08 -0.03333333333333333 \
 1.371885714285714e-08 -0.1 \
 1.372678571428571e-08 -0.1 \
 1.372778571428571e-08 -0.1 \
 1.373571428571429e-08 -0.1 \
 1.373671428571429e-08 -0.1 \
 1.374464285714286e-08 -0.1 \
 1.374564285714286e-08 0.03333333333333333 \
 1.375357142857143e-08 0.03333333333333333 \
 1.375457142857143e-08 0.03333333333333333 \
 1.37625e-08 0.03333333333333333 \
 1.37635e-08 0.03333333333333333 \
 1.377142857142857e-08 0.03333333333333333 \
 1.377242857142857e-08 -0.03333333333333333 \
 1.378035714285714e-08 -0.03333333333333333 \
 1.378135714285714e-08 -0.03333333333333333 \
 1.378928571428571e-08 -0.03333333333333333 \
 1.379028571428571e-08 0.03333333333333333 \
 1.379821428571429e-08 0.03333333333333333 \
 1.379921428571429e-08 -0.03333333333333333 \
 1.380714285714286e-08 -0.03333333333333333 \
 1.380814285714286e-08 -0.03333333333333333 \
 1.381607142857143e-08 -0.03333333333333333 \
 1.381707142857143e-08 0.03333333333333333 \
 1.3825e-08 0.03333333333333333 \
 1.3826e-08 -0.03333333333333333 \
 1.383392857142857e-08 -0.03333333333333333 \
 1.383492857142857e-08 0.1 \
 1.384285714285714e-08 0.1 \
 1.384385714285714e-08 -0.1 \
 1.385178571428571e-08 -0.1 \
 1.385278571428571e-08 0.03333333333333333 \
 1.386071428571429e-08 0.03333333333333333 \
 1.386171428571428e-08 -0.1 \
 1.386964285714286e-08 -0.1 \
 1.387064285714286e-08 -0.03333333333333333 \
 1.387857142857143e-08 -0.03333333333333333 \
 1.387957142857143e-08 -0.1 \
 1.38875e-08 -0.1 \
 1.38885e-08 -0.1 \
 1.389642857142857e-08 -0.1 \
 1.389742857142857e-08 0.03333333333333333 \
 1.390535714285714e-08 0.03333333333333333 \
 1.390635714285714e-08 0.03333333333333333 \
 1.391428571428571e-08 0.03333333333333333 \
 1.391528571428571e-08 -0.03333333333333333 \
 1.392321428571429e-08 -0.03333333333333333 \
 1.392421428571428e-08 0.03333333333333333 \
 1.393214285714286e-08 0.03333333333333333 \
 1.393314285714286e-08 -0.1 \
 1.394107142857143e-08 -0.1 \
 1.394207142857143e-08 -0.03333333333333333 \
 1.395e-08 -0.03333333333333333 \
 1.3951e-08 -0.1 \
 1.395892857142857e-08 -0.1 \
 1.395992857142857e-08 0.03333333333333333 \
 1.396785714285714e-08 0.03333333333333333 \
 1.396885714285714e-08 0.03333333333333333 \
 1.397678571428571e-08 0.03333333333333333 \
 1.397778571428571e-08 -0.1 \
 1.398571428571428e-08 -0.1 \
 1.398671428571428e-08 0.03333333333333333 \
 1.399464285714286e-08 0.03333333333333333 \
 1.399564285714286e-08 0.1 \
 1.400357142857143e-08 0.1 \
 1.400457142857143e-08 0.03333333333333333 \
 1.40125e-08 0.03333333333333333 \
 1.40135e-08 0.1 \
 1.402142857142857e-08 0.1 \
 1.402242857142857e-08 0.03333333333333333 \
 1.403035714285714e-08 0.03333333333333333 \
 1.403135714285714e-08 0.1 \
 1.403928571428571e-08 0.1 \
 1.404028571428571e-08 -0.03333333333333333 \
 1.404821428571429e-08 -0.03333333333333333 \
 1.404921428571429e-08 -0.03333333333333333 \
 1.405714285714286e-08 -0.03333333333333333 \
 1.405814285714286e-08 0.03333333333333333 \
 1.406607142857143e-08 0.03333333333333333 \
 1.406707142857143e-08 0.03333333333333333 \
 1.4075e-08 0.03333333333333333 \
 1.4076e-08 0.03333333333333333 \
 1.408392857142857e-08 0.03333333333333333 \
 1.408492857142857e-08 -0.03333333333333333 \
 1.409285714285714e-08 -0.03333333333333333 \
 1.409385714285714e-08 -0.1 \
 1.410178571428571e-08 -0.1 \
 1.410278571428571e-08 -0.1 \
 1.411071428571429e-08 -0.1 \
 1.411171428571429e-08 -0.03333333333333333 \
 1.411964285714286e-08 -0.03333333333333333 \
 1.412064285714286e-08 0.03333333333333333 \
 1.412857142857143e-08 0.03333333333333333 \
 1.412957142857143e-08 0.1 \
 1.41375e-08 0.1 \
 1.41385e-08 -0.1 \
 1.414642857142857e-08 -0.1 \
 1.414742857142857e-08 0.03333333333333333 \
 1.415535714285714e-08 0.03333333333333333 \
 1.415635714285714e-08 -0.03333333333333333 \
 1.416428571428571e-08 -0.03333333333333333 \
 1.416528571428571e-08 -0.03333333333333333 \
 1.417321428571429e-08 -0.03333333333333333 \
 1.417421428571429e-08 -0.1 \
 1.418214285714286e-08 -0.1 \
 1.418314285714286e-08 -0.03333333333333333 \
 1.419107142857143e-08 -0.03333333333333333 \
 1.419207142857143e-08 -0.03333333333333333 \
 1.42e-08 -0.03333333333333333 \
 1.4201e-08 0.1 \
 1.420892857142857e-08 0.1 \
 1.420992857142857e-08 0.1 \
 1.421785714285714e-08 0.1 \
 1.421885714285714e-08 -0.03333333333333333 \
 1.422678571428571e-08 -0.03333333333333333 \
 1.422778571428571e-08 0.1 \
 1.423571428571429e-08 0.1 \
 1.423671428571429e-08 -0.03333333333333333 \
 1.424464285714286e-08 -0.03333333333333333 \
 1.424564285714286e-08 0.03333333333333333 \
 1.425357142857143e-08 0.03333333333333333 \
 1.425457142857143e-08 -0.1 \
 1.42625e-08 -0.1 \
 1.42635e-08 0.03333333333333333 \
 1.427142857142857e-08 0.03333333333333333 \
 1.427242857142857e-08 -0.1 \
 1.428035714285714e-08 -0.1 \
 1.428135714285714e-08 -0.03333333333333333 \
 1.428928571428571e-08 -0.03333333333333333 \
 1.429028571428571e-08 0.03333333333333333 \
 1.429821428571429e-08 0.03333333333333333 \
 1.429921428571428e-08 0.1 \
 1.430714285714286e-08 0.1 \
 1.430814285714286e-08 0.1 \
 1.431607142857143e-08 0.1 \
 1.431707142857143e-08 0.1 \
 1.4325e-08 0.1 \
 1.4326e-08 0.03333333333333333 \
 1.433392857142857e-08 0.03333333333333333 \
 1.433492857142857e-08 -0.03333333333333333 \
 1.434285714285714e-08 -0.03333333333333333 \
 1.434385714285714e-08 0.03333333333333333 \
 1.435178571428571e-08 0.03333333333333333 \
 1.435278571428571e-08 -0.03333333333333333 \
 1.436071428571429e-08 -0.03333333333333333 \
 1.436171428571428e-08 -0.03333333333333333 \
 1.436964285714286e-08 -0.03333333333333333 \
 1.437064285714286e-08 0.03333333333333333 \
 1.437857142857143e-08 0.03333333333333333 \
 1.437957142857143e-08 0.03333333333333333 \
 1.43875e-08 0.03333333333333333 \
 1.43885e-08 -0.03333333333333333 \
 1.439642857142857e-08 -0.03333333333333333 \
 1.439742857142857e-08 -0.03333333333333333 \
 1.440535714285714e-08 -0.03333333333333333 \
 1.440635714285714e-08 -0.03333333333333333 \
 1.441428571428571e-08 -0.03333333333333333 \
 1.441528571428571e-08 0.03333333333333333 \
 1.442321428571429e-08 0.03333333333333333 \
 1.442421428571429e-08 0.1 \
 1.443214285714286e-08 0.1 \
 1.443314285714286e-08 -0.03333333333333333 \
 1.444107142857143e-08 -0.03333333333333333 \
 1.444207142857143e-08 -0.1 \
 1.445e-08 -0.1 \
 1.4451e-08 -0.03333333333333333 \
 1.445892857142857e-08 -0.03333333333333333 \
 1.445992857142857e-08 0.03333333333333333 \
 1.446785714285714e-08 0.03333333333333333 \
 1.446885714285714e-08 0.03333333333333333 \
 1.447678571428571e-08 0.03333333333333333 \
 1.447778571428571e-08 0.03333333333333333 \
 1.448571428571429e-08 0.03333333333333333 \
 1.448671428571429e-08 -0.1 \
 1.449464285714286e-08 -0.1 \
 1.449564285714286e-08 -0.1 \
 1.450357142857143e-08 -0.1 \
 1.450457142857143e-08 -0.1 \
 1.45125e-08 -0.1 \
 1.45135e-08 0.1 \
 1.452142857142857e-08 0.1 \
 1.452242857142857e-08 -0.03333333333333333 \
 1.453035714285714e-08 -0.03333333333333333 \
 1.453135714285714e-08 -0.03333333333333333 \
 1.453928571428571e-08 -0.03333333333333333 \
 1.454028571428571e-08 -0.03333333333333333 \
 1.454821428571429e-08 -0.03333333333333333 \
 1.454921428571429e-08 -0.1 \
 1.455714285714286e-08 -0.1 \
 1.455814285714286e-08 -0.1 \
 1.456607142857143e-08 -0.1 \
 1.456707142857143e-08 -0.03333333333333333 \
 1.4575e-08 -0.03333333333333333 \
 1.4576e-08 0.1 \
 1.458392857142857e-08 0.1 \
 1.458492857142857e-08 0.03333333333333333 \
 1.459285714285714e-08 0.03333333333333333 \
 1.459385714285714e-08 -0.03333333333333333 \
 1.460178571428571e-08 -0.03333333333333333 \
 1.460278571428571e-08 0.03333333333333333 \
 1.461071428571429e-08 0.03333333333333333 \
 1.461171428571429e-08 -0.03333333333333333 \
 1.461964285714286e-08 -0.03333333333333333 \
 1.462064285714286e-08 0.03333333333333333 \
 1.462857142857143e-08 0.03333333333333333 \
 1.462957142857143e-08 -0.1 \
 1.46375e-08 -0.1 \
 1.46385e-08 -0.1 \
 1.464642857142857e-08 -0.1 \
 1.464742857142857e-08 -0.1 \
 1.465535714285714e-08 -0.1 \
 1.465635714285714e-08 -0.1 \
 1.466428571428571e-08 -0.1 \
 1.466528571428571e-08 0.03333333333333333 \
 1.467321428571429e-08 0.03333333333333333 \
 1.467421428571428e-08 -0.03333333333333333 \
 1.468214285714286e-08 -0.03333333333333333 \
 1.468314285714286e-08 0.03333333333333333 \
 1.469107142857143e-08 0.03333333333333333 \
 1.469207142857143e-08 -0.03333333333333333 \
 1.47e-08 -0.03333333333333333 \
 1.4701e-08 -0.1 \
 1.470892857142857e-08 -0.1 \
 1.470992857142857e-08 0.03333333333333333 \
 1.471785714285714e-08 0.03333333333333333 \
 1.471885714285714e-08 0.1 \
 1.472678571428571e-08 0.1 \
 1.472778571428571e-08 0.1 \
 1.473571428571429e-08 0.1 \
 1.473671428571428e-08 -0.1 \
 1.474464285714286e-08 -0.1 \
 1.474564285714286e-08 -0.1 \
 1.475357142857143e-08 -0.1 \
 1.475457142857143e-08 -0.03333333333333333 \
 1.47625e-08 -0.03333333333333333 \
 1.47635e-08 -0.03333333333333333 \
 1.477142857142857e-08 -0.03333333333333333 \
 1.477242857142857e-08 -0.03333333333333333 \
 1.478035714285714e-08 -0.03333333333333333 \
 1.478135714285714e-08 -0.1 \
 1.478928571428571e-08 -0.1 \
 1.479028571428571e-08 0.1 \
 1.479821428571428e-08 0.1 \
 1.479921428571428e-08 0.1 \
 1.480714285714286e-08 0.1 \
 1.480814285714286e-08 0.03333333333333333 \
 1.481607142857143e-08 0.03333333333333333 \
 1.481707142857143e-08 0.03333333333333333 \
 1.4825e-08 0.03333333333333333 \
 1.4826e-08 0.1 \
 1.483392857142857e-08 0.1 \
 1.483492857142857e-08 -0.03333333333333333 \
 1.484285714285714e-08 -0.03333333333333333 \
 1.484385714285714e-08 -0.03333333333333333 \
 1.485178571428571e-08 -0.03333333333333333 \
 1.485278571428571e-08 0.1 \
 1.486071428571429e-08 0.1 \
 1.486171428571429e-08 0.1 \
 1.486964285714286e-08 0.1 \
 1.487064285714286e-08 -0.1 \
 1.487857142857143e-08 -0.1 \
 1.487957142857143e-08 -0.03333333333333333 \
 1.48875e-08 -0.03333333333333333 \
 1.48885e-08 0.03333333333333333 \
 1.489642857142857e-08 0.03333333333333333 \
 1.489742857142857e-08 0.03333333333333333 \
 1.490535714285714e-08 0.03333333333333333 \
 1.490635714285714e-08 -0.1 \
 1.491428571428571e-08 -0.1 \
 1.491528571428572e-08 -0.1 \
 1.492321428571428e-08 -0.1 \
 1.492421428571429e-08 0.1 \
 1.493214285714286e-08 0.1 \
 1.493314285714286e-08 0.03333333333333333 \
 1.494107142857143e-08 0.03333333333333333 \
 1.494207142857143e-08 -0.03333333333333333 \
 1.495e-08 -0.03333333333333333 \
 1.4951e-08 0.1 \
 1.495892857142857e-08 0.1 \
 1.495992857142857e-08 -0.1 \
 1.496785714285714e-08 -0.1 \
 1.496885714285714e-08 0.03333333333333333 \
 1.497678571428571e-08 0.03333333333333333 \
 1.497778571428571e-08 0.1 \
 1.498571428571429e-08 0.1 \
 1.498671428571429e-08 0.03333333333333333 \
 1.499464285714286e-08 0.03333333333333333 \
 1.499564285714286e-08 -0.1 \
 1.500357142857143e-08 -0.1 \
 1.500457142857143e-08 -0.1 \
 1.50125e-08 -0.1 \
 1.50135e-08 -0.1 \
 1.502142857142857e-08 -0.1 \
 1.502242857142857e-08 -0.03333333333333333 \
 1.503035714285714e-08 -0.03333333333333333 \
 1.503135714285714e-08 0.03333333333333333 \
 1.503928571428571e-08 0.03333333333333333 \
 1.504028571428571e-08 0.1 \
 1.504821428571428e-08 0.1 \
 1.504921428571428e-08 0.03333333333333333 \
 1.505714285714286e-08 0.03333333333333333 \
 1.505814285714286e-08 0.1 \
 1.506607142857143e-08 0.1 \
 1.506707142857143e-08 0.03333333333333333 \
 1.5075e-08 0.03333333333333333 \
 1.5076e-08 0.03333333333333333 \
 1.508392857142857e-08 0.03333333333333333 \
 1.508492857142857e-08 -0.1 \
 1.509285714285714e-08 -0.1 \
 1.509385714285714e-08 0.03333333333333333 \
 1.510178571428571e-08 0.03333333333333333 \
 1.510278571428571e-08 -0.03333333333333333 \
 1.511071428571429e-08 -0.03333333333333333 \
 1.511171428571429e-08 0.1 \
 1.511964285714286e-08 0.1 \
 1.512064285714286e-08 0.03333333333333333 \
 1.512857142857143e-08 0.03333333333333333 \
 1.512957142857143e-08 0.1 \
 1.51375e-08 0.1 \
 1.51385e-08 0.03333333333333333 \
 1.514642857142857e-08 0.03333333333333333 \
 1.514742857142857e-08 -0.1 \
 1.515535714285714e-08 -0.1 \
 1.515635714285714e-08 0.1 \
 1.516428571428571e-08 0.1 \
 1.516528571428571e-08 0.03333333333333333 \
 1.517321428571428e-08 0.03333333333333333 \
 1.517421428571428e-08 0.1 \
 1.518214285714286e-08 0.1 \
 1.518314285714286e-08 -0.1 \
 1.519107142857143e-08 -0.1 \
 1.519207142857143e-08 -0.03333333333333333 \
 1.52e-08 -0.03333333333333333 \
 1.5201e-08 0.1 \
 1.520892857142857e-08 0.1 \
 1.520992857142857e-08 0.03333333333333333 \
 1.521785714285714e-08 0.03333333333333333 \
 1.521885714285714e-08 -0.03333333333333333 \
 1.522678571428571e-08 -0.03333333333333333 \
 1.522778571428571e-08 0.1 \
 1.523571428571428e-08 0.1 \
 1.523671428571429e-08 -0.1 \
 1.524464285714285e-08 -0.1 \
 1.524564285714286e-08 0.03333333333333333 \
 1.525357142857143e-08 0.03333333333333333 \
 1.525457142857143e-08 0.03333333333333333 \
 1.52625e-08 0.03333333333333333 \
 1.52635e-08 0.1 \
 1.527142857142857e-08 0.1 \
 1.527242857142857e-08 -0.03333333333333333 \
 1.528035714285714e-08 -0.03333333333333333 \
 1.528135714285714e-08 -0.1 \
 1.528928571428571e-08 -0.1 \
 1.529028571428571e-08 -0.03333333333333333 \
 1.529821428571428e-08 -0.03333333333333333 \
 1.529921428571428e-08 -0.1 \
 1.530714285714286e-08 -0.1 \
 1.530814285714286e-08 0.03333333333333333 \
 1.531607142857143e-08 0.03333333333333333 \
 1.531707142857143e-08 0.1 \
 1.5325e-08 0.1 \
 1.5326e-08 -0.1 \
 1.533392857142857e-08 -0.1 \
 1.533492857142857e-08 0.1 \
 1.534285714285714e-08 0.1 \
 1.534385714285714e-08 -0.03333333333333333 \
 1.535178571428571e-08 -0.03333333333333333 \
 1.535278571428571e-08 -0.03333333333333333 \
 1.536071428571428e-08 -0.03333333333333333 \
 1.536171428571429e-08 0.1 \
 1.536964285714285e-08 0.1 \
 1.537064285714286e-08 -0.03333333333333333 \
 1.537857142857143e-08 -0.03333333333333333 \
 1.537957142857143e-08 -0.1 \
 1.53875e-08 -0.1 \
 1.53885e-08 -0.03333333333333333 \
 1.539642857142857e-08 -0.03333333333333333 \
 1.539742857142857e-08 0.1 \
 1.540535714285714e-08 0.1 \
 1.540635714285714e-08 0.1 \
 1.541428571428571e-08 0.1 \
 1.541528571428571e-08 -0.1 \
 1.542321428571429e-08 -0.1 \
 1.542421428571429e-08 0.03333333333333333 \
 1.543214285714286e-08 0.03333333333333333 \
 1.543314285714286e-08 -0.03333333333333333 \
 1.544107142857143e-08 -0.03333333333333333 \
 1.544207142857143e-08 0.03333333333333333 \
 1.545e-08 0.03333333333333333 \
 1.5451e-08 0.1 \
 1.545892857142857e-08 0.1 \
 1.545992857142857e-08 -0.03333333333333333 \
 1.546785714285714e-08 -0.03333333333333333 \
 1.546885714285714e-08 0.03333333333333333 \
 1.547678571428571e-08 0.03333333333333333 \
 1.547778571428571e-08 -0.03333333333333333 \
 1.548571428571428e-08 -0.03333333333333333 \
 1.548671428571428e-08 -0.03333333333333333 \
 1.549464285714286e-08 -0.03333333333333333 \
 1.549564285714286e-08 -0.1 \
 1.550357142857143e-08 -0.1 \
 1.550457142857143e-08 0.1 \
 1.55125e-08 0.1 \
 1.55135e-08 0.03333333333333333 \
 1.552142857142857e-08 0.03333333333333333 \
 1.552242857142857e-08 0.03333333333333333 \
 1.553035714285714e-08 0.03333333333333333 \
 1.553135714285714e-08 -0.1 \
 1.553928571428571e-08 -0.1 \
 1.554028571428571e-08 -0.03333333333333333 \
 1.554821428571428e-08 -0.03333333333333333 \
 1.554921428571429e-08 -0.1 \
 1.555714285714286e-08 -0.1 \
 1.555814285714286e-08 0.03333333333333333 \
 1.556607142857143e-08 0.03333333333333333 \
 1.556707142857143e-08 0.1 \
 1.5575e-08 0.1 \
 1.5576e-08 -0.03333333333333333 \
 1.558392857142857e-08 -0.03333333333333333 \
 1.558492857142857e-08 -0.03333333333333333 \
 1.559285714285714e-08 -0.03333333333333333 \
 1.559385714285714e-08 0.03333333333333333 \
 1.560178571428571e-08 0.03333333333333333 \
 1.560278571428571e-08 0.1 \
 1.561071428571428e-08 0.1 \
 1.561171428571428e-08 -0.1 \
 1.561964285714286e-08 -0.1 \
 1.562064285714286e-08 -0.03333333333333333 \
 1.562857142857143e-08 -0.03333333333333333 \
 1.562957142857143e-08 0.03333333333333333 \
 1.56375e-08 0.03333333333333333 \
 1.56385e-08 -0.03333333333333333 \
 1.564642857142857e-08 -0.03333333333333333 \
 1.564742857142857e-08 -0.03333333333333333 \
 1.565535714285714e-08 -0.03333333333333333 \
 1.565635714285714e-08 -0.1 \
 1.566428571428571e-08 -0.1 \
 1.566528571428572e-08 -0.1 \
 1.567321428571428e-08 -0.1 \
 1.567421428571429e-08 0.03333333333333333 \
 1.568214285714285e-08 0.03333333333333333 \
 1.568314285714286e-08 0.03333333333333333 \
 1.569107142857143e-08 0.03333333333333333 \
 1.569207142857143e-08 0.1 \
 1.57e-08 0.1 \
 1.5701e-08 0.03333333333333333 \
 1.570892857142857e-08 0.03333333333333333 \
 1.570992857142857e-08 -0.03333333333333333 \
 1.571785714285714e-08 -0.03333333333333333 \
 1.571885714285714e-08 -0.03333333333333333 \
 1.572678571428571e-08 -0.03333333333333333 \
 1.572778571428571e-08 0.1 \
 1.573571428571428e-08 0.1 \
 1.573671428571428e-08 -0.1 \
 1.574464285714286e-08 -0.1 \
 1.574564285714286e-08 -0.03333333333333333 \
 1.575357142857143e-08 -0.03333333333333333 \
 1.575457142857143e-08 -0.1 \
 1.57625e-08 -0.1 \
 1.57635e-08 0.1 \
 1.577142857142857e-08 0.1 \
 1.577242857142857e-08 0.03333333333333333 \
 1.578035714285714e-08 0.03333333333333333 \
 1.578135714285714e-08 0.1 \
 1.578928571428571e-08 0.1 \
 1.579028571428571e-08 0.03333333333333333 \
 1.579821428571428e-08 0.03333333333333333 \
 1.579921428571428e-08 -0.03333333333333333 \
 1.580714285714285e-08 -0.03333333333333333 \
 1.580814285714286e-08 -0.1 \
 1.581607142857143e-08 -0.1 \
 1.581707142857143e-08 -0.1 \
 1.5825e-08 -0.1 \
 1.5826e-08 -0.1 \
 1.583392857142857e-08 -0.1 \
 1.583492857142857e-08 -0.1 \
 1.584285714285714e-08 -0.1 \
 1.584385714285714e-08 -0.03333333333333333 \
 1.585178571428571e-08 -0.03333333333333333 \
 1.585278571428571e-08 -0.03333333333333333 \
 1.586071428571429e-08 -0.03333333333333333 \
 1.586171428571429e-08 -0.1 \
 1.586964285714286e-08 -0.1 \
 1.587064285714286e-08 -0.03333333333333333 \
 1.587857142857143e-08 -0.03333333333333333 \
 1.587957142857143e-08 -0.03333333333333333 \
 1.58875e-08 -0.03333333333333333 \
 1.58885e-08 -0.03333333333333333 \
 1.589642857142857e-08 -0.03333333333333333 \
 1.589742857142857e-08 0.1 \
 1.590535714285714e-08 0.1 \
 1.590635714285714e-08 0.1 \
 1.591428571428571e-08 0.1 \
 1.591528571428571e-08 -0.03333333333333333 \
 1.592321428571428e-08 -0.03333333333333333 \
 1.592421428571428e-08 -0.03333333333333333 \
 1.593214285714286e-08 -0.03333333333333333 \
 1.593314285714286e-08 -0.1 \
 1.594107142857143e-08 -0.1 \
 1.594207142857143e-08 -0.03333333333333333 \
 1.595e-08 -0.03333333333333333 \
 1.5951e-08 -0.03333333333333333 \
 1.595892857142857e-08 -0.03333333333333333 \
 1.595992857142857e-08 -0.1 \
 1.596785714285714e-08 -0.1 \
 1.596885714285714e-08 0.1 \
 1.597678571428571e-08 0.1 \
 1.597778571428571e-08 -0.03333333333333333 \
 1.598571428571428e-08 -0.03333333333333333 \
 1.598671428571429e-08 -0.03333333333333333 \
 1.599464285714285e-08 -0.03333333333333333 \
 1.599564285714286e-08 0.1 \
 1.600357142857143e-08 0.1 \
 1.600457142857143e-08 -0.03333333333333333 \
 1.60125e-08 -0.03333333333333333 \
 1.60135e-08 0.03333333333333333 \
 1.602142857142857e-08 0.03333333333333333 \
 1.602242857142857e-08 -0.03333333333333333 \
 1.603035714285714e-08 -0.03333333333333333 \
 1.603135714285714e-08 0.1 \
 1.603928571428571e-08 0.1 \
 1.604028571428571e-08 -0.03333333333333333 \
 1.604821428571428e-08 -0.03333333333333333 \
 1.604921428571428e-08 -0.1 \
 1.605714285714286e-08 -0.1 \
 1.605814285714286e-08 -0.1 \
 1.606607142857143e-08 -0.1 \
 1.606707142857143e-08 -0.03333333333333333 \
 1.6075e-08 -0.03333333333333333 \
 1.6076e-08 0.03333333333333333 \
 1.608392857142857e-08 0.03333333333333333 \
 1.608492857142857e-08 -0.03333333333333333 \
 1.609285714285714e-08 -0.03333333333333333 \
 1.609385714285714e-08 -0.03333333333333333 \
 1.610178571428571e-08 -0.03333333333333333 \
 1.610278571428572e-08 -0.03333333333333333 \
 1.611071428571428e-08 -0.03333333333333333 \
 1.611171428571429e-08 -0.03333333333333333 \
 1.611964285714285e-08 -0.03333333333333333 \
 1.612064285714286e-08 -0.1 \
 1.612857142857143e-08 -0.1 \
 1.612957142857143e-08 -0.03333333333333333 \
 1.61375e-08 -0.03333333333333333 \
 1.61385e-08 -0.1 \
 1.614642857142857e-08 -0.1 \
 1.614742857142857e-08 -0.1 \
 1.615535714285714e-08 -0.1 \
 1.615635714285714e-08 0.03333333333333333 \
 1.616428571428571e-08 0.03333333333333333 \
 1.616528571428571e-08 0.1 \
 1.617321428571429e-08 0.1 \
 1.617421428571429e-08 -0.03333333333333333 \
 1.618214285714286e-08 -0.03333333333333333 \
 1.618314285714286e-08 0.1 \
 1.619107142857143e-08 0.1 \
 1.619207142857143e-08 0.03333333333333333 \
 1.62e-08 0.03333333333333333 \
 1.6201e-08 -0.03333333333333333 \
 1.620892857142857e-08 -0.03333333333333333 \
 1.620992857142857e-08 0.03333333333333333 \
 1.621785714285714e-08 0.03333333333333333 \
 1.621885714285714e-08 0.03333333333333333 \
 1.622678571428571e-08 0.03333333333333333 \
 1.622778571428571e-08 -0.1 \
 1.623571428571428e-08 -0.1 \
 1.623671428571428e-08 0.1 \
 1.624464285714285e-08 0.1 \
 1.624564285714285e-08 -0.03333333333333333 \
 1.625357142857143e-08 -0.03333333333333333 \
 1.625457142857143e-08 -0.1 \
 1.62625e-08 -0.1 \
 1.62635e-08 -0.1 \
 1.627142857142857e-08 -0.1 \
 1.627242857142857e-08 -0.03333333333333333 \
 1.628035714285714e-08 -0.03333333333333333 \
 1.628135714285714e-08 0.1 \
 1.628928571428571e-08 0.1 \
 1.629028571428571e-08 -0.1 \
 1.629821428571429e-08 -0.1 \
 1.629921428571429e-08 -0.03333333333333333 \
 1.630714285714286e-08 -0.03333333333333333 \
 1.630814285714286e-08 -0.03333333333333333 \
 1.631607142857143e-08 -0.03333333333333333 \
 1.631707142857143e-08 0.1 \
 1.6325e-08 0.1 \
 1.6326e-08 0.1 \
 1.633392857142857e-08 0.1 \
 1.633492857142857e-08 0.03333333333333333 \
 1.634285714285714e-08 0.03333333333333333 \
 1.634385714285714e-08 -0.1 \
 1.635178571428571e-08 -0.1 \
 1.635278571428571e-08 0.1 \
 1.636071428571428e-08 0.1 \
 1.636171428571428e-08 -0.03333333333333333 \
 1.636964285714286e-08 -0.03333333333333333 \
 1.637064285714286e-08 0.1 \
 1.637857142857143e-08 0.1 \
 1.637957142857143e-08 -0.1 \
 1.63875e-08 -0.1 \
 1.63885e-08 0.1 \
 1.639642857142857e-08 0.1 \
 1.639742857142857e-08 -0.03333333333333333 \
 1.640535714285714e-08 -0.03333333333333333 \
 1.640635714285714e-08 -0.03333333333333333 \
 1.641428571428571e-08 -0.03333333333333333 \
 1.641528571428571e-08 0.03333333333333333 \
 1.642321428571428e-08 0.03333333333333333 \
 1.642421428571429e-08 0.1 \
 1.643214285714285e-08 0.1 \
 1.643314285714286e-08 -0.1 \
 1.644107142857143e-08 -0.1 \
 1.644207142857143e-08 -0.1 \
 1.645e-08 -0.1 \
 1.6451e-08 -0.1 \
 1.645892857142857e-08 -0.1 \
 1.645992857142857e-08 -0.03333333333333333 \
 1.646785714285714e-08 -0.03333333333333333 \
 1.646885714285714e-08 0.03333333333333333 \
 1.647678571428571e-08 0.03333333333333333 \
 1.647778571428571e-08 -0.1 \
 1.648571428571428e-08 -0.1 \
 1.648671428571428e-08 -0.1 \
 1.649464285714286e-08 -0.1 \
 1.649564285714286e-08 -0.03333333333333333 \
 1.650357142857143e-08 -0.03333333333333333 \
 1.650457142857143e-08 -0.03333333333333333 \
 1.65125e-08 -0.03333333333333333 \
 1.65135e-08 -0.1 \
 1.652142857142857e-08 -0.1 \
 1.652242857142857e-08 0.1 \
 1.653035714285714e-08 0.1 \
 1.653135714285714e-08 -0.03333333333333333 \
 1.653928571428571e-08 -0.03333333333333333 \
 1.654028571428571e-08 -0.1 \
 1.654821428571428e-08 -0.1 \
 1.654921428571429e-08 0.03333333333333333 \
 1.655714285714285e-08 0.03333333333333333 \
 1.655814285714286e-08 0.03333333333333333 \
 1.656607142857143e-08 0.03333333333333333 \
 1.656707142857143e-08 -0.1 \
 1.6575e-08 -0.1 \
 1.6576e-08 -0.03333333333333333 \
 1.658392857142857e-08 -0.03333333333333333 \
 1.658492857142857e-08 0.1 \
 1.659285714285714e-08 0.1 \
 1.659385714285714e-08 0.1 \
 1.660178571428571e-08 0.1 \
 1.660278571428571e-08 0.1 \
 1.661071428571429e-08 0.1 \
 1.661171428571429e-08 -0.1 \
 1.661964285714286e-08 -0.1 \
 1.662064285714286e-08 0.03333333333333333 \
 1.662857142857143e-08 0.03333333333333333 \
 1.662957142857143e-08 0.1 \
 1.66375e-08 0.1 \
 1.66385e-08 0.1 \
 1.664642857142857e-08 0.1 \
 1.664742857142857e-08 -0.03333333333333333 \
 1.665535714285714e-08 -0.03333333333333333 \
 1.665635714285714e-08 -0.1 \
 1.666428571428571e-08 -0.1 \
 1.666528571428571e-08 0.1 \
 1.667321428571428e-08 0.1 \
 1.667421428571428e-08 -0.1 \
 1.668214285714286e-08 -0.1 \
 1.668314285714286e-08 0.1 \
 1.669107142857143e-08 0.1 \
 1.669207142857143e-08 0.03333333333333333 \
 1.67e-08 0.03333333333333333 \
 1.6701e-08 -0.03333333333333333 \
 1.670892857142857e-08 -0.03333333333333333 \
 1.670992857142857e-08 0.03333333333333333 \
 1.671785714285714e-08 0.03333333333333333 \
 1.671885714285714e-08 -0.03333333333333333 \
 1.672678571428571e-08 -0.03333333333333333 \
 1.672778571428571e-08 -0.1 \
 1.673571428571428e-08 -0.1 \
 1.673671428571429e-08 0.03333333333333333 \
 1.674464285714285e-08 0.03333333333333333 \
 1.674564285714286e-08 -0.03333333333333333 \
 1.675357142857143e-08 -0.03333333333333333 \
 1.675457142857143e-08 -0.1 \
 1.67625e-08 -0.1 \
 1.67635e-08 0.1 \
 1.677142857142857e-08 0.1 \
 1.677242857142857e-08 0.03333333333333333 \
 1.678035714285714e-08 0.03333333333333333 \
 1.678135714285714e-08 -0.03333333333333333 \
 1.678928571428571e-08 -0.03333333333333333 \
 1.679028571428571e-08 -0.03333333333333333 \
 1.679821428571428e-08 -0.03333333333333333 \
 1.679921428571428e-08 -0.03333333333333333 \
 1.680714285714286e-08 -0.03333333333333333 \
 1.680814285714286e-08 -0.1 \
 1.681607142857143e-08 -0.1 \
 1.681707142857143e-08 0.03333333333333333 \
 1.6825e-08 0.03333333333333333 \
 1.6826e-08 -0.03333333333333333 \
 1.683392857142857e-08 -0.03333333333333333 \
 1.683492857142857e-08 0.03333333333333333 \
 1.684285714285714e-08 0.03333333333333333 \
 1.684385714285714e-08 -0.03333333333333333 \
 1.685178571428571e-08 -0.03333333333333333 \
 1.685278571428572e-08 0.1 \
 1.686071428571428e-08 0.1 \
 1.686171428571429e-08 -0.1 \
 1.686964285714285e-08 -0.1 \
 1.687064285714286e-08 -0.03333333333333333 \
 1.687857142857143e-08 -0.03333333333333333 \
 1.687957142857143e-08 -0.1 \
 1.68875e-08 -0.1 \
 1.68885e-08 -0.03333333333333333 \
 1.689642857142857e-08 -0.03333333333333333 \
 1.689742857142857e-08 -0.1 \
 1.690535714285714e-08 -0.1 \
 1.690635714285714e-08 0.03333333333333333 \
 1.691428571428571e-08 0.03333333333333333 \
 1.691528571428571e-08 -0.03333333333333333 \
 1.692321428571428e-08 -0.03333333333333333 \
 1.692421428571428e-08 0.1 \
 1.693214285714286e-08 0.1 \
 1.693314285714286e-08 0.1 \
 1.694107142857143e-08 0.1 \
 1.694207142857143e-08 0.1 \
 1.695e-08 0.1 \
 1.6951e-08 -0.03333333333333333 \
 1.695892857142857e-08 -0.03333333333333333 \
 1.695992857142857e-08 0.1 \
 1.696785714285714e-08 0.1 \
 1.696885714285714e-08 -0.1 \
 1.697678571428571e-08 -0.1 \
 1.697778571428571e-08 -0.1 \
 1.698571428571428e-08 -0.1 \
 1.698671428571428e-08 -0.03333333333333333 \
 1.699464285714285e-08 -0.03333333333333333 \
 1.699564285714286e-08 -0.1 \
 1.700357142857143e-08 -0.1 \
 1.700457142857143e-08 -0.1 \
 1.70125e-08 -0.1 \
 1.70135e-08 0.1 \
 1.702142857142857e-08 0.1 \
 1.702242857142857e-08 0.03333333333333333 \
 1.703035714285714e-08 0.03333333333333333 \
 1.703135714285714e-08 -0.03333333333333333 \
 1.703928571428571e-08 -0.03333333333333333 \
 1.704028571428571e-08 -0.03333333333333333 \
 1.704821428571429e-08 -0.03333333333333333 \
 1.704921428571429e-08 -0.03333333333333333 \
 1.705714285714286e-08 -0.03333333333333333 \
 1.705814285714286e-08 0.03333333333333333 \
 1.706607142857143e-08 0.03333333333333333 \
 1.706707142857143e-08 -0.03333333333333333 \
 1.7075e-08 -0.03333333333333333 \
 1.7076e-08 -0.1 \
 1.708392857142857e-08 -0.1 \
 1.708492857142857e-08 0.1 \
 1.709285714285714e-08 0.1 \
 1.709385714285714e-08 0.1 \
 1.710178571428571e-08 0.1 \
 1.710278571428571e-08 0.03333333333333333 \
 1.711071428571428e-08 0.03333333333333333 \
 1.711171428571428e-08 0.03333333333333333 \
 1.711964285714286e-08 0.03333333333333333 \
 1.712064285714286e-08 0.1 \
 1.712857142857143e-08 0.1 \
 1.712957142857143e-08 -0.03333333333333333 \
 1.71375e-08 -0.03333333333333333 \
 1.71385e-08 -0.03333333333333333 \
 1.714642857142857e-08 -0.03333333333333333 \
 1.714742857142857e-08 0.03333333333333333 \
 1.715535714285714e-08 0.03333333333333333 \
 1.715635714285714e-08 0.03333333333333333 \
 1.716428571428571e-08 0.03333333333333333 \
 1.716528571428571e-08 -0.1 \
 1.717321428571428e-08 -0.1 \
 1.717421428571429e-08 -0.1 \
 1.718214285714285e-08 -0.1 \
 1.718314285714286e-08 0.03333333333333333 \
 1.719107142857143e-08 0.03333333333333333 \
 1.719207142857143e-08 -0.1 \
 1.72e-08 -0.1 \
 1.7201e-08 0.1 \
 1.720892857142857e-08 0.1 \
 1.720992857142857e-08 0.03333333333333333 \
 1.721785714285714e-08 0.03333333333333333 \
 1.721885714285714e-08 -0.03333333333333333 \
 1.722678571428571e-08 -0.03333333333333333 \
 1.722778571428571e-08 -0.03333333333333333 \
 1.723571428571428e-08 -0.03333333333333333 \
 1.723671428571428e-08 -0.1 \
 1.724464285714286e-08 -0.1 \
 1.724564285714286e-08 -0.1 \
 1.725357142857143e-08 -0.1 \
 1.725457142857143e-08 -0.1 \
 1.72625e-08 -0.1 \
 1.72635e-08 0.1 \
 1.727142857142857e-08 0.1 \
 1.727242857142857e-08 0.1 \
 1.728035714285714e-08 0.1 \
 1.728135714285714e-08 -0.03333333333333333 \
 1.728928571428571e-08 -0.03333333333333333 \
 1.729028571428571e-08 -0.1 \
 1.729821428571428e-08 -0.1 \
 1.729921428571429e-08 0.1 \
 1.730714285714285e-08 0.1 \
 1.730814285714286e-08 -0.1 \
 1.731607142857143e-08 -0.1 \
 1.731707142857143e-08 0.03333333333333333 \
 1.7325e-08 0.03333333333333333 \
 1.7326e-08 0.03333333333333333 \
 1.733392857142857e-08 0.03333333333333333 \
 1.733492857142857e-08 0.03333333333333333 \
 1.734285714285714e-08 0.03333333333333333 \
 1.734385714285714e-08 0.1 \
 1.735178571428571e-08 0.1 \
 1.735278571428571e-08 0.1 \
 1.736071428571429e-08 0.1 \
 1.736171428571429e-08 0.1 \
 1.736964285714286e-08 0.1 \
 1.737064285714286e-08 -0.1 \
 1.737857142857143e-08 -0.1 \
 1.737957142857143e-08 -0.1 \
 1.73875e-08 -0.1 \
 1.73885e-08 -0.1 \
 1.739642857142857e-08 -0.1 \
 1.739742857142857e-08 0.1 \
 1.740535714285714e-08 0.1 \
 1.740635714285714e-08 0.03333333333333333 \
 1.741428571428571e-08 0.03333333333333333 \
 1.741528571428571e-08 0.03333333333333333 \
 1.742321428571428e-08 0.03333333333333333 \
 1.742421428571428e-08 -0.03333333333333333 \
 1.743214285714285e-08 -0.03333333333333333 \
 1.743314285714285e-08 -0.03333333333333333 \
 1.744107142857143e-08 -0.03333333333333333 \
 1.744207142857143e-08 -0.1 \
 1.745e-08 -0.1 \
 1.7451e-08 -0.03333333333333333 \
 1.745892857142857e-08 -0.03333333333333333 \
 1.745992857142857e-08 0.03333333333333333 \
 1.746785714285714e-08 0.03333333333333333 \
 1.746885714285714e-08 -0.1 \
 1.747678571428571e-08 -0.1 \
 1.747778571428571e-08 -0.1 \
 1.748571428571428e-08 -0.1 \
 1.748671428571429e-08 0.03333333333333333 \
 1.749464285714286e-08 0.03333333333333333 \
 1.749564285714286e-08 0.03333333333333333 \
 1.750357142857143e-08 0.03333333333333333 \
 1.750457142857143e-08 0.1 \
 1.75125e-08 0.1 \
 1.75135e-08 0.1 \
 1.752142857142857e-08 0.1 \
 1.752242857142857e-08 0.1 \
 1.753035714285714e-08 0.1 \
 1.753135714285714e-08 0.03333333333333333 \
 1.753928571428571e-08 0.03333333333333333 \
 1.754028571428571e-08 0.03333333333333333 \
 1.754821428571428e-08 0.03333333333333333 \
 1.754921428571428e-08 0.1 \
 1.755714285714286e-08 0.1 \
 1.755814285714286e-08 -0.03333333333333333 \
 1.756607142857143e-08 -0.03333333333333333 \
 1.756707142857143e-08 -0.1 \
 1.7575e-08 -0.1 \
 1.7576e-08 -0.1 \
 1.758392857142857e-08 -0.1 \
 1.758492857142857e-08 0.03333333333333333 \
 1.759285714285714e-08 0.03333333333333333 \
 1.759385714285714e-08 0.03333333333333333 \
 1.760178571428571e-08 0.03333333333333333 \
 1.760278571428572e-08 -0.1 \
 1.761071428571428e-08 -0.1 \
 1.761171428571429e-08 0.1 \
 1.761964285714285e-08 0.1 \
 1.762064285714286e-08 -0.03333333333333333 \
 1.762857142857143e-08 -0.03333333333333333 \
 1.762957142857143e-08 -0.1 \
 1.76375e-08 -0.1 \
 1.76385e-08 0.03333333333333333 \
 1.764642857142857e-08 0.03333333333333333 \
 1.764742857142857e-08 0.03333333333333333 \
 1.765535714285714e-08 0.03333333333333333 \
 1.765635714285714e-08 0.03333333333333333 \
 1.766428571428571e-08 0.03333333333333333 \
 1.766528571428571e-08 -0.03333333333333333 \
 1.767321428571428e-08 -0.03333333333333333 \
 1.767421428571428e-08 -0.1 \
 1.768214285714286e-08 -0.1 \
 1.768314285714286e-08 0.03333333333333333 \
 1.769107142857143e-08 0.03333333333333333 \
 1.769207142857143e-08 -0.1 \
 1.77e-08 -0.1 \
 1.7701e-08 -0.03333333333333333 \
 1.770892857142857e-08 -0.03333333333333333 \
 1.770992857142857e-08 0.1 \
 1.771785714285714e-08 0.1 \
 1.771885714285714e-08 -0.03333333333333333 \
 1.772678571428571e-08 -0.03333333333333333 \
 1.772778571428571e-08 -0.03333333333333333 \
 1.773571428571428e-08 -0.03333333333333333 \
 1.773671428571428e-08 0.03333333333333333 \
 1.774464285714285e-08 0.03333333333333333 \
 1.774564285714286e-08 -0.03333333333333333 \
 1.775357142857143e-08 -0.03333333333333333 \
 1.775457142857143e-08 -0.1 \
 1.77625e-08 -0.1 \
 1.77635e-08 -0.03333333333333333 \
 1.777142857142857e-08 -0.03333333333333333 \
 1.777242857142857e-08 -0.1 \
 1.778035714285714e-08 -0.1 \
 1.778135714285714e-08 0.03333333333333333 \
 1.778928571428571e-08 0.03333333333333333 \
 1.779028571428571e-08 0.03333333333333333 \
 1.779821428571429e-08 0.03333333333333333 \
 1.779921428571429e-08 0.03333333333333333 \
 1.780714285714286e-08 0.03333333333333333 \
 1.780814285714286e-08 0.1 \
 1.781607142857143e-08 0.1 \
 1.781707142857143e-08 -0.03333333333333333 \
 1.7825e-08 -0.03333333333333333 \
 1.7826e-08 -0.03333333333333333 \
 1.783392857142857e-08 -0.03333333333333333 \
 1.783492857142857e-08 -0.03333333333333333 \
 1.784285714285714e-08 -0.03333333333333333 \
 1.784385714285714e-08 -0.1 \
 1.785178571428571e-08 -0.1 \
 1.785278571428571e-08 -0.1 \
 1.786071428571428e-08 -0.1 \
 1.786171428571428e-08 0.1 \
 1.786964285714286e-08 0.1 \
 1.787064285714286e-08 0.1 \
 1.787857142857143e-08 0.1 \
 1.787957142857143e-08 0.1 \
 1.78875e-08 0.1 \
 1.78885e-08 -0.1 \
 1.789642857142857e-08 -0.1 \
 1.789742857142857e-08 0.03333333333333333 \
 1.790535714285714e-08 0.03333333333333333 \
 1.790635714285714e-08 0.03333333333333333 \
 1.791428571428571e-08 0.03333333333333333 \
 1.791528571428571e-08 -0.1 \
 1.792321428571428e-08 -0.1 \
 1.792421428571429e-08 0.1 \
 1.793214285714285e-08 0.1 \
 1.793314285714286e-08 0.03333333333333333 \
 1.794107142857143e-08 0.03333333333333333 \
 1.794207142857143e-08 -0.1 \
 1.795e-08 -0.1 \
 1.7951e-08 0.1 \
 1.795892857142857e-08 0.1 \
 1.795992857142857e-08 -0.03333333333333333 \
 1.796785714285714e-08 -0.03333333333333333 \
 1.796885714285714e-08 -0.1 \
 1.797678571428571e-08 -0.1 \
 1.797778571428571e-08 0.03333333333333333 \
 1.798571428571428e-08 0.03333333333333333 \
 1.798671428571428e-08 -0.1 \
 1.799464285714286e-08 -0.1 \
 1.799564285714286e-08 0.1 \
 1.800357142857143e-08 0.1 \
 1.800457142857143e-08 0.03333333333333333 \
 1.80125e-08 0.03333333333333333 \
 1.80135e-08 -0.1 \
 1.802142857142857e-08 -0.1 \
 1.802242857142857e-08 0.1 \
 1.803035714285714e-08 0.1 \
 1.803135714285714e-08 0.1 \
 1.803928571428571e-08 0.1 \
 1.804028571428572e-08 0.1 \
 1.804821428571428e-08 0.1 \
 1.804921428571429e-08 -0.03333333333333333 \
 1.805714285714285e-08 -0.03333333333333333 \
 1.805814285714286e-08 0.03333333333333333 \
 1.806607142857143e-08 0.03333333333333333 \
 1.806707142857143e-08 -0.03333333333333333 \
 1.8075e-08 -0.03333333333333333 \
 1.8076e-08 -0.1 \
 1.808392857142857e-08 -0.1 \
 1.808492857142857e-08 0.1 \
 1.809285714285714e-08 0.1 \
 1.809385714285714e-08 0.1 \
 1.810178571428571e-08 0.1 \
 1.810278571428571e-08 0.1 \
 1.811071428571429e-08 0.1 \
 1.811171428571429e-08 0.1 \
 1.811964285714286e-08 0.1 \
 1.812064285714286e-08 0.1 \
 1.812857142857143e-08 0.1 \
 1.812957142857143e-08 0.1 \
 1.81375e-08 0.1 \
 1.81385e-08 0.1 \
 1.814642857142857e-08 0.1 \
 1.814742857142857e-08 -0.1 \
 1.815535714285714e-08 -0.1 \
 1.815635714285714e-08 0.03333333333333333 \
 1.816428571428571e-08 0.03333333333333333 \
 1.816528571428571e-08 -0.1 \
 1.817321428571428e-08 -0.1 \
 1.817421428571428e-08 0.03333333333333333 \
 1.818214285714285e-08 0.03333333333333333 \
 1.818314285714285e-08 0.03333333333333333 \
 1.819107142857143e-08 0.03333333333333333 \
 1.819207142857143e-08 0.1 \
 1.82e-08 0.1 \
 1.8201e-08 0.1 \
 1.820892857142857e-08 0.1 \
 1.820992857142857e-08 -0.1 \
 1.821785714285714e-08 -0.1 \
 1.821885714285714e-08 -0.03333333333333333 \
 1.822678571428571e-08 -0.03333333333333333 \
 1.822778571428571e-08 -0.1 \
 1.823571428571428e-08 -0.1 \
 1.823671428571429e-08 0.1 \
 1.824464285714286e-08 0.1 \
 1.824564285714286e-08 -0.1 \
 1.825357142857143e-08 -0.1 \
 1.825457142857143e-08 -0.03333333333333333 \
 1.82625e-08 -0.03333333333333333 \
 1.82635e-08 -0.1 \
 1.827142857142857e-08 -0.1 \
 1.827242857142857e-08 -0.03333333333333333 \
 1.828035714285714e-08 -0.03333333333333333 \
 1.828135714285714e-08 -0.03333333333333333 \
 1.828928571428571e-08 -0.03333333333333333 \
 1.829028571428571e-08 0.03333333333333333 \
 1.829821428571428e-08 0.03333333333333333 \
 1.829921428571428e-08 -0.03333333333333333 \
 1.830714285714286e-08 -0.03333333333333333 \
 1.830814285714286e-08 0.1 \
 1.831607142857143e-08 0.1 \
 1.831707142857143e-08 0.1 \
 1.8325e-08 0.1 \
 1.8326e-08 -0.1 \
 1.833392857142857e-08 -0.1 \
 1.833492857142857e-08 -0.03333333333333333 \
 1.834285714285714e-08 -0.03333333333333333 \
 1.834385714285714e-08 -0.1 \
 1.835178571428571e-08 -0.1 \
 1.835278571428571e-08 0.03333333333333333 \
 1.836071428571428e-08 0.03333333333333333 \
 1.836171428571429e-08 0.03333333333333333 \
 1.836964285714285e-08 0.03333333333333333 \
 1.837064285714286e-08 -0.1 \
 1.837857142857143e-08 -0.1 \
 1.837957142857143e-08 0.1 \
 1.83875e-08 0.1 \
 1.83885e-08 0.1 \
 1.839642857142857e-08 0.1 \
 1.839742857142857e-08 0.1 \
 1.840535714285714e-08 0.1 \
 1.840635714285714e-08 -0.03333333333333333 \
 1.841428571428571e-08 -0.03333333333333333 \
 1.841528571428571e-08 0.1 \
 1.842321428571428e-08 0.1 \
 1.842421428571428e-08 0.03333333333333333 \
 1.843214285714286e-08 0.03333333333333333 \
 1.843314285714286e-08 -0.1 \
 1.844107142857143e-08 -0.1 \
 1.844207142857143e-08 0.1 \
 1.845e-08 0.1 \
 1.8451e-08 0.1 \
 1.845892857142857e-08 0.1 \
 1.845992857142857e-08 0.03333333333333333 \
 1.846785714285714e-08 0.03333333333333333 \
 1.846885714285714e-08 0.03333333333333333 \
 1.847678571428571e-08 0.03333333333333333 \
 1.847778571428571e-08 0.1 \
 1.848571428571428e-08 0.1 \
 1.848671428571429e-08 -0.03333333333333333 \
 1.849464285714285e-08 -0.03333333333333333 \
 1.849564285714286e-08 0.1 \
 1.850357142857143e-08 0.1 \
 1.850457142857143e-08 0.1 \
 1.85125e-08 0.1 \
 1.85135e-08 0.1 \
 1.852142857142857e-08 0.1 \
 1.852242857142857e-08 0.03333333333333333 \
 1.853035714285714e-08 0.03333333333333333 \
 1.853135714285714e-08 0.1 \
 1.853928571428571e-08 0.1 \
 1.854028571428571e-08 -0.1 \
 1.854821428571429e-08 -0.1 \
 1.854921428571429e-08 -0.03333333333333333 \
 1.855714285714286e-08 -0.03333333333333333 \
 1.855814285714286e-08 0.03333333333333333 \
 1.856607142857143e-08 0.03333333333333333 \
 1.856707142857143e-08 0.1 \
 1.8575e-08 0.1 \
 1.8576e-08 0.1 \
 1.858392857142857e-08 0.1 \
 1.858492857142857e-08 -0.1 \
 1.859285714285714e-08 -0.1 \
 1.859385714285714e-08 0.1 \
 1.860178571428571e-08 0.1 \
 1.860278571428571e-08 0.1 \
 1.861071428571428e-08 0.1 \
 1.861171428571428e-08 0.1 \
 1.861964285714286e-08 0.1 \
 1.862064285714286e-08 -0.03333333333333333 \
 1.862857142857143e-08 -0.03333333333333333 \
 1.862957142857143e-08 0.1 \
 1.86375e-08 0.1 \
 1.86385e-08 -0.03333333333333333 \
 1.864642857142857e-08 -0.03333333333333333 \
 1.864742857142857e-08 0.03333333333333333 \
 1.865535714285714e-08 0.03333333333333333 \
 1.865635714285714e-08 0.1 \
 1.866428571428571e-08 0.1 \
 1.866528571428571e-08 0.03333333333333333 \
 1.867321428571428e-08 0.03333333333333333 \
 1.867421428571429e-08 0.03333333333333333 \
 1.868214285714285e-08 0.03333333333333333 \
 1.868314285714286e-08 0.1 \
 1.869107142857143e-08 0.1 \
 1.869207142857143e-08 -0.1 \
 1.87e-08 -0.1 \
 1.8701e-08 -0.1 \
 1.870892857142857e-08 -0.1 \
 1.870992857142857e-08 -0.1 \
 1.871785714285714e-08 -0.1 \
 1.871885714285714e-08 0.1 \
 1.872678571428571e-08 0.1 \
 1.872778571428571e-08 0.1 \
 1.873571428571428e-08 0.1 \
 1.873671428571428e-08 0.03333333333333333 \
 1.874464285714286e-08 0.03333333333333333 \
 1.874564285714286e-08 0.1 \
 1.875357142857143e-08 0.1 \
 1.875457142857143e-08 0.1 \
 1.87625e-08 0.1 \
 1.87635e-08 0.03333333333333333 \
 1.877142857142857e-08 0.03333333333333333 \
 1.877242857142857e-08 0.1 \
 1.878035714285714e-08 0.1 \
 1.878135714285714e-08 -0.03333333333333333 \
 1.878928571428571e-08 -0.03333333333333333 \
 1.879028571428572e-08 -0.03333333333333333 \
 1.879821428571428e-08 -0.03333333333333333 \
 1.879921428571429e-08 0.1 \
 1.880714285714285e-08 0.1 \
 1.880814285714286e-08 -0.03333333333333333 \
 1.881607142857143e-08 -0.03333333333333333 \
 1.881707142857143e-08 0.03333333333333333 \
 1.8825e-08 0.03333333333333333 \
 1.8826e-08 0.1 \
 1.883392857142857e-08 0.1 \
 1.883492857142857e-08 0.1 \
 1.884285714285714e-08 0.1 \
 1.884385714285714e-08 0.1 \
 1.885178571428571e-08 0.1 \
 1.885278571428571e-08 -0.03333333333333333 \
 1.886071428571428e-08 -0.03333333333333333 \
 1.886171428571428e-08 0.1 \
 1.886964285714286e-08 0.1 \
 1.887064285714286e-08 0.03333333333333333 \
 1.887857142857143e-08 0.03333333333333333 \
 1.887957142857143e-08 0.1 \
 1.88875e-08 0.1 \
 1.88885e-08 -0.1 \
 1.889642857142857e-08 -0.1 \
 1.889742857142857e-08 0.03333333333333333 \
 1.890535714285714e-08 0.03333333333333333 \
 1.890635714285714e-08 -0.1 \
 1.891428571428571e-08 -0.1 \
 1.891528571428571e-08 -0.03333333333333333 \
 1.892321428571428e-08 -0.03333333333333333 \
 1.892421428571428e-08 -0.1 \
 1.893214285714285e-08 -0.1 \
 1.893314285714286e-08 -0.03333333333333333 \
 1.894107142857143e-08 -0.03333333333333333 \
 1.894207142857143e-08 -0.03333333333333333 \
 1.895e-08 -0.03333333333333333 \
 1.8951e-08 0.03333333333333333 \
 1.895892857142857e-08 0.03333333333333333 \
 1.895992857142857e-08 0.1 \
 1.896785714285714e-08 0.1 \
 1.896885714285714e-08 -0.03333333333333333 \
 1.897678571428571e-08 -0.03333333333333333 \
 1.897778571428571e-08 0.03333333333333333 \
 1.898571428571429e-08 0.03333333333333333 \
 1.898671428571429e-08 0.03333333333333333 \
 1.899464285714286e-08 0.03333333333333333 \
 1.899564285714286e-08 -0.03333333333333333 \
 1.900357142857143e-08 -0.03333333333333333 \
 1.900457142857143e-08 -0.1 \
 1.90125e-08 -0.1 \
 1.90135e-08 -0.03333333333333333 \
 1.902142857142857e-08 -0.03333333333333333 \
 1.902242857142857e-08 -0.1 \
 1.903035714285714e-08 -0.1 \
 1.903135714285714e-08 -0.1 \
 1.903928571428571e-08 -0.1 \
 1.904028571428571e-08 0.03333333333333333 \
 1.904821428571428e-08 0.03333333333333333 \
 1.904921428571428e-08 -0.1 \
 1.905714285714286e-08 -0.1 \
 1.905814285714286e-08 0.03333333333333333 \
 1.906607142857143e-08 0.03333333333333333 \
 1.906707142857143e-08 -0.03333333333333333 \
 1.9075e-08 -0.03333333333333333 \
 1.9076e-08 0.1 \
 1.908392857142857e-08 0.1 \
 1.908492857142857e-08 0.1 \
 1.909285714285714e-08 0.1 \
 1.909385714285714e-08 0.03333333333333333 \
 1.910178571428571e-08 0.03333333333333333 \
 1.910278571428571e-08 0.1 \
 1.911071428571428e-08 0.1 \
 1.911171428571429e-08 0.03333333333333333 \
 1.911964285714285e-08 0.03333333333333333 \
 1.912064285714286e-08 0.1 \
 1.912857142857143e-08 0.1 \
 1.912957142857143e-08 0.03333333333333333 \
 1.91375e-08 0.03333333333333333 \
 1.91385e-08 0.1 \
 1.914642857142857e-08 0.1 \
 1.914742857142857e-08 -0.03333333333333333 \
 1.915535714285714e-08 -0.03333333333333333 \
 1.915635714285714e-08 0.03333333333333333 \
 1.916428571428571e-08 0.03333333333333333 \
 1.916528571428571e-08 0.1 \
 1.917321428571428e-08 0.1 \
 1.917421428571428e-08 0.1 \
 1.918214285714286e-08 0.1 \
 1.918314285714286e-08 0.1 \
 1.919107142857143e-08 0.1 \
 1.919207142857143e-08 -0.1 \
 1.92e-08 -0.1 \
 1.9201e-08 0.1 \
 1.920892857142857e-08 0.1 \
 1.920992857142857e-08 -0.1 \
 1.921785714285714e-08 -0.1 \
 1.921885714285714e-08 0.03333333333333333 \
 1.922678571428571e-08 0.03333333333333333 \
 1.922778571428571e-08 0.1 \
 1.923571428571428e-08 0.1 \
 1.923671428571429e-08 0.1 \
 1.924464285714285e-08 0.1 \
 1.924564285714286e-08 -0.1 \
 1.925357142857143e-08 -0.1 \
 1.925457142857143e-08 -0.1 \
 1.92625e-08 -0.1 \
 1.92635e-08 0.03333333333333333 \
 1.927142857142857e-08 0.03333333333333333 \
 1.927242857142857e-08 0.03333333333333333 \
 1.928035714285714e-08 0.03333333333333333 \
 1.928135714285714e-08 0.1 \
 1.928928571428571e-08 0.1 \
 1.929028571428571e-08 -0.03333333333333333 \
 1.929821428571429e-08 -0.03333333333333333 \
 1.929921428571429e-08 0.1 \
 1.930714285714286e-08 0.1 \
 1.930814285714286e-08 -0.03333333333333333 \
 1.931607142857143e-08 -0.03333333333333333 \
 1.931707142857143e-08 0.1 \
 1.9325e-08 0.1 \
 1.9326e-08 -0.03333333333333333 \
 1.933392857142857e-08 -0.03333333333333333 \
 1.933492857142857e-08 0.03333333333333333 \
 1.934285714285714e-08 0.03333333333333333 \
 1.934385714285714e-08 0.1 \
 1.935178571428571e-08 0.1 \
 1.935278571428571e-08 0.03333333333333333 \
 1.936071428571428e-08 0.03333333333333333 \
 1.936171428571428e-08 0.03333333333333333 \
 1.936964285714285e-08 0.03333333333333333 \
 1.937064285714285e-08 -0.1 \
 1.937857142857143e-08 -0.1 \
 1.937957142857143e-08 -0.03333333333333333 \
 1.93875e-08 -0.03333333333333333 \
 1.93885e-08 0.03333333333333333 \
 1.939642857142857e-08 0.03333333333333333 \
 1.939742857142857e-08 0.1 \
 1.940535714285714e-08 0.1 \
 1.940635714285714e-08 0.1 \
 1.941428571428571e-08 0.1 \
 1.941528571428571e-08 0.1 \
 1.942321428571428e-08 0.1 \
 1.942421428571429e-08 -0.1 \
 1.943214285714286e-08 -0.1 \
 1.943314285714286e-08 -0.03333333333333333 \
 1.944107142857143e-08 -0.03333333333333333 \
 1.944207142857143e-08 0.1 \
 1.945e-08 0.1 \
 1.9451e-08 -0.03333333333333333 \
 1.945892857142857e-08 -0.03333333333333333 \
 1.945992857142857e-08 -0.03333333333333333 \
 1.946785714285714e-08 -0.03333333333333333 \
 1.946885714285714e-08 -0.1 \
 1.947678571428571e-08 -0.1 \
 1.947778571428571e-08 0.03333333333333333 \
 1.948571428571428e-08 0.03333333333333333 \
 1.948671428571428e-08 -0.1 \
 1.949464285714286e-08 -0.1 \
 1.949564285714286e-08 0.03333333333333333 \
 1.950357142857143e-08 0.03333333333333333 \
 1.950457142857143e-08 0.03333333333333333 \
 1.95125e-08 0.03333333333333333 \
 1.95135e-08 -0.1 \
 1.952142857142857e-08 -0.1 \
 1.952242857142857e-08 -0.03333333333333333 \
 1.953035714285714e-08 -0.03333333333333333 \
 1.953135714285714e-08 -0.03333333333333333 \
 1.953928571428571e-08 -0.03333333333333333 \
 1.954028571428572e-08 0.1 \
 1.954821428571428e-08 0.1 \
 1.954921428571429e-08 -0.03333333333333333 \
 1.955714285714285e-08 -0.03333333333333333 \
 1.955814285714286e-08 -0.1 \
 1.956607142857143e-08 -0.1 \
 1.956707142857143e-08 0.1 \
 1.9575e-08 0.1 \
 1.9576e-08 -0.1 \
 1.958392857142857e-08 -0.1 \
 1.958492857142857e-08 -0.03333333333333333 \
 1.959285714285714e-08 -0.03333333333333333 \
 1.959385714285714e-08 -0.03333333333333333 \
 1.960178571428571e-08 -0.03333333333333333 \
 1.960278571428571e-08 0.03333333333333333 \
 1.961071428571428e-08 0.03333333333333333 \
 1.961171428571428e-08 -0.1 \
 1.961964285714286e-08 -0.1 \
 1.962064285714286e-08 -0.1 \
 1.962857142857143e-08 -0.1 \
 1.962957142857143e-08 0.03333333333333333 \
 1.96375e-08 0.03333333333333333 \
 1.96385e-08 0.1 \
 1.964642857142857e-08 0.1 \
 1.964742857142857e-08 -0.03333333333333333 \
 1.965535714285714e-08 -0.03333333333333333 \
 1.965635714285714e-08 0.1 \
 1.966428571428571e-08 0.1 \
 1.966528571428571e-08 -0.03333333333333333 \
 1.967321428571428e-08 -0.03333333333333333 \
 1.967421428571428e-08 0.03333333333333333 \
 1.968214285714285e-08 0.03333333333333333 \
 1.968314285714286e-08 0.03333333333333333 \
 1.969107142857143e-08 0.03333333333333333 \
 1.969207142857143e-08 0.03333333333333333 \
 1.97e-08 0.03333333333333333 \
 1.9701e-08 -0.03333333333333333 \
 1.970892857142857e-08 -0.03333333333333333 \
 1.970992857142857e-08 0.03333333333333333 \
 1.971785714285714e-08 0.03333333333333333 \
 1.971885714285714e-08 0.03333333333333333 \
 1.972678571428571e-08 0.03333333333333333 \
 1.972778571428571e-08 -0.03333333333333333 \
 1.973571428571429e-08 -0.03333333333333333 \
 1.973671428571429e-08 0.03333333333333333 \
 1.974464285714286e-08 0.03333333333333333 \
 1.974564285714286e-08 -0.03333333333333333 \
 1.975357142857143e-08 -0.03333333333333333 \
 1.975457142857143e-08 -0.03333333333333333 \
 1.97625e-08 -0.03333333333333333 \
 1.97635e-08 0.1 \
 1.977142857142857e-08 0.1 \
 1.977242857142857e-08 -0.1 \
 1.978035714285714e-08 -0.1 \
 1.978135714285714e-08 -0.1 \
 1.978928571428571e-08 -0.1 \
 1.979028571428571e-08 0.03333333333333333 \
 1.979821428571428e-08 0.03333333333333333 \
 1.979921428571428e-08 0.1 \
 1.980714285714286e-08 0.1 \
 1.980814285714286e-08 0.1 \
 1.981607142857143e-08 0.1 \
 1.981707142857143e-08 -0.03333333333333333 \
 1.9825e-08 -0.03333333333333333 \
 1.9826e-08 -0.03333333333333333 \
 1.983392857142857e-08 -0.03333333333333333 \
 1.983492857142857e-08 -0.1 \
 1.984285714285714e-08 -0.1 \
 1.984385714285714e-08 0.1 \
 1.985178571428571e-08 0.1 \
 1.985278571428571e-08 -0.03333333333333333 \
 1.986071428571428e-08 -0.03333333333333333 \
 1.986171428571429e-08 0.1 \
 1.986964285714285e-08 0.1 \
 1.987064285714286e-08 -0.03333333333333333 \
 1.987857142857143e-08 -0.03333333333333333 \
 1.987957142857143e-08 -0.03333333333333333 \
 1.98875e-08 -0.03333333333333333 \
 1.98885e-08 -0.1 \
 1.989642857142857e-08 -0.1 \
 1.989742857142857e-08 -0.1 \
 1.990535714285714e-08 -0.1 \
 1.990635714285714e-08 0.03333333333333333 \
 1.991428571428571e-08 0.03333333333333333 \
 1.991528571428571e-08 -0.1 \
 1.992321428571428e-08 -0.1 \
 1.992421428571428e-08 -0.1 \
 1.993214285714286e-08 -0.1 \
 1.993314285714286e-08 -0.1 \
 1.994107142857143e-08 -0.1 \
 1.994207142857143e-08 -0.1 \
 1.995e-08 -0.1 \
 1.9951e-08 0.1 \
 1.995892857142857e-08 0.1 \
 1.995992857142857e-08 -0.1 \
 1.996785714285714e-08 -0.1 \
 1.996885714285714e-08 -0.03333333333333333 \
 1.997678571428571e-08 -0.03333333333333333 \
 1.997778571428572e-08 0.1 \
 1.998571428571428e-08 0.1 \
 1.998671428571429e-08 0.1 \
 1.999464285714285e-08 0.1 \
 1.999564285714286e-08 -0.03333333333333333 \
 2.000357142857143e-08 -0.03333333333333333 \
 2.000457142857143e-08 -0.1 \
 2.00125e-08 -0.1 \
 2.00135e-08 0.1 \
 2.002142857142857e-08 0.1 \
 2.002242857142857e-08 0.1 \
 2.003035714285714e-08 0.1 \
 2.003135714285714e-08 -0.1 \
 2.003928571428571e-08 -0.1 \
 2.004028571428571e-08 -0.03333333333333333 \
 2.004821428571429e-08 -0.03333333333333333 \
 2.004921428571429e-08 -0.03333333333333333 \
 2.005714285714286e-08 -0.03333333333333333 \
 2.005814285714286e-08 0.03333333333333333 \
 2.006607142857143e-08 0.03333333333333333 \
 2.006707142857143e-08 0.03333333333333333 \
 2.0075e-08 0.03333333333333333 \
 2.0076e-08 0.03333333333333333 \
 2.008392857142857e-08 0.03333333333333333 \
 2.008492857142857e-08 -0.1 \
 2.009285714285714e-08 -0.1 \
 2.009385714285714e-08 0.03333333333333333 \
 2.010178571428571e-08 0.03333333333333333 \
 2.010278571428571e-08 0.03333333333333333 \
 2.011071428571428e-08 0.03333333333333333 \
 2.011171428571428e-08 0.03333333333333333 \
 2.011964285714285e-08 0.03333333333333333 \
 2.012064285714285e-08 -0.1 \
 2.012857142857143e-08 -0.1 \
 2.012957142857143e-08 -0.1 \
 2.01375e-08 -0.1 \
 2.01385e-08 0.1 \
 2.014642857142857e-08 0.1 \
 2.014742857142857e-08 0.03333333333333333 \
 2.015535714285714e-08 0.03333333333333333 \
 2.015635714285714e-08 -0.1 \
 2.016428571428571e-08 -0.1 \
 2.016528571428571e-08 0.1 \
 2.017321428571428e-08 0.1 \
 2.017421428571429e-08 -0.1 \
 2.018214285714286e-08 -0.1 \
 2.018314285714286e-08 0.1 \
 2.019107142857143e-08 0.1 \
 2.019207142857143e-08 0.03333333333333333 \
 2.02e-08 0.03333333333333333 \
 2.0201e-08 0.1 \
 2.020892857142857e-08 0.1 \
 2.020992857142857e-08 -0.03333333333333333 \
 2.021785714285714e-08 -0.03333333333333333 \
 2.021885714285714e-08 0.03333333333333333 \
 2.022678571428571e-08 0.03333333333333333 \
 2.022778571428571e-08 -0.03333333333333333 \
 2.023571428571428e-08 -0.03333333333333333 \
 2.023671428571428e-08 0.03333333333333333 \
 2.024464285714286e-08 0.03333333333333333 \
 2.024564285714286e-08 -0.1 \
 2.025357142857143e-08 -0.1 \
 2.025457142857143e-08 0.03333333333333333 \
 2.02625e-08 0.03333333333333333 \
 2.02635e-08 0.03333333333333333 \
 2.027142857142857e-08 0.03333333333333333 \
 2.027242857142857e-08 0.1 \
 2.028035714285714e-08 0.1 \
 2.028135714285714e-08 -0.03333333333333333 \
 2.028928571428571e-08 -0.03333333333333333 \
 2.029028571428571e-08 0.03333333333333333 \
 2.029821428571428e-08 0.03333333333333333 \
 2.029921428571429e-08 0.03333333333333333 \
 2.030714285714285e-08 0.03333333333333333 \
 2.030814285714286e-08 -0.03333333333333333 \
 2.031607142857143e-08 -0.03333333333333333 \
 2.031707142857143e-08 0.03333333333333333 \
 2.0325e-08 0.03333333333333333 \
 2.0326e-08 0.1 \
 2.033392857142857e-08 0.1 \
 2.033492857142857e-08 -0.1 \
 2.034285714285714e-08 -0.1 \
 2.034385714285714e-08 0.1 \
 2.035178571428571e-08 0.1 \
 2.035278571428571e-08 -0.1 \
 2.036071428571428e-08 -0.1 \
 2.036171428571428e-08 0.03333333333333333 \
 2.036964285714286e-08 0.03333333333333333 \
 2.037064285714286e-08 -0.1 \
 2.037857142857143e-08 -0.1 \
 2.037957142857143e-08 0.03333333333333333 \
 2.03875e-08 0.03333333333333333 \
 2.03885e-08 0.03333333333333333 \
 2.039642857142857e-08 0.03333333333333333 \
 2.039742857142857e-08 0.1 \
 2.040535714285714e-08 0.1 \
 2.040635714285714e-08 -0.1 \
 2.041428571428571e-08 -0.1 \
 2.041528571428571e-08 -0.03333333333333333 \
 2.042321428571428e-08 -0.03333333333333333 \
 2.042421428571429e-08 0.03333333333333333 \
 2.043214285714285e-08 0.03333333333333333 \
 2.043314285714286e-08 0.03333333333333333 \
 2.044107142857143e-08 0.03333333333333333 \
 2.044207142857143e-08 -0.03333333333333333 \
 2.045e-08 -0.03333333333333333 \
 2.0451e-08 -0.1 \
 2.045892857142857e-08 -0.1 \
 2.045992857142857e-08 0.1 \
 2.046785714285714e-08 0.1 \
 2.046885714285714e-08 -0.1 \
 2.047678571428571e-08 -0.1 \
 2.047778571428571e-08 -0.03333333333333333 \
 2.048571428571429e-08 -0.03333333333333333 \
 2.048671428571429e-08 -0.03333333333333333 \
 2.049464285714286e-08 -0.03333333333333333 \
 2.049564285714286e-08 0.1 \
 2.050357142857143e-08 0.1 \
 2.050457142857143e-08 -0.03333333333333333 \
 2.05125e-08 -0.03333333333333333 \
 2.05135e-08 -0.03333333333333333 \
 2.052142857142857e-08 -0.03333333333333333 \
 2.052242857142857e-08 0.1 \
 2.053035714285714e-08 0.1 \
 2.053135714285714e-08 -0.1 \
 2.053928571428571e-08 -0.1 \
 2.054028571428571e-08 -0.03333333333333333 \
 2.054821428571428e-08 -0.03333333333333333 \
 2.054921428571428e-08 -0.1 \
 2.055714285714286e-08 -0.1 \
 2.055814285714286e-08 -0.03333333333333333 \
 2.056607142857143e-08 -0.03333333333333333 \
 2.056707142857143e-08 -0.1 \
 2.0575e-08 -0.1 \
 2.0576e-08 0.03333333333333333 \
 2.058392857142857e-08 0.03333333333333333 \
 2.058492857142857e-08 0.03333333333333333 \
 2.059285714285714e-08 0.03333333333333333 \
 2.059385714285714e-08 0.1 \
 2.060178571428571e-08 0.1 \
 2.060278571428571e-08 0.03333333333333333 \
 2.061071428571428e-08 0.03333333333333333 \
 2.061171428571429e-08 0.03333333333333333 \
 2.061964285714285e-08 0.03333333333333333 \
 2.062064285714286e-08 0.1 \
 2.062857142857143e-08 0.1 \
 2.062957142857143e-08 -0.03333333333333333 \
 2.06375e-08 -0.03333333333333333 \
 2.06385e-08 0.03333333333333333 \
 2.064642857142857e-08 0.03333333333333333 \
 2.064742857142857e-08 0.1 \
 2.065535714285714e-08 0.1 \
 2.065635714285714e-08 -0.03333333333333333 \
 2.066428571428571e-08 -0.03333333333333333 \
 2.066528571428571e-08 -0.03333333333333333 \
 2.067321428571428e-08 -0.03333333333333333 \
 2.067421428571428e-08 0.03333333333333333 \
 2.068214285714286e-08 0.03333333333333333 \
 2.068314285714286e-08 -0.1 \
 2.069107142857143e-08 -0.1 \
 2.069207142857143e-08 0.03333333333333333 \
 2.07e-08 0.03333333333333333 \
 2.0701e-08 0.1 \
 2.070892857142857e-08 0.1 \
 2.070992857142857e-08 -0.03333333333333333 \
 2.071785714285714e-08 -0.03333333333333333 \
 2.071885714285714e-08 0.03333333333333333 \
 2.072678571428571e-08 0.03333333333333333 \
 2.072778571428572e-08 -0.1 \
 2.073571428571428e-08 -0.1 \
 2.073671428571429e-08 -0.1 \
 2.074464285714285e-08 -0.1 \
 2.074564285714286e-08 0.1 \
 2.075357142857143e-08 0.1 \
 2.075457142857143e-08 0.03333333333333333 \
 2.07625e-08 0.03333333333333333 \
 2.07635e-08 0.03333333333333333 \
 2.077142857142857e-08 0.03333333333333333 \
 2.077242857142857e-08 -0.03333333333333333 \
 2.078035714285714e-08 -0.03333333333333333 \
 2.078135714285714e-08 0.03333333333333333 \
 2.078928571428571e-08 0.03333333333333333 \
 2.079028571428571e-08 -0.1 \
 2.079821428571428e-08 -0.1 \
 2.079921428571428e-08 -0.03333333333333333 \
 2.080714285714286e-08 -0.03333333333333333 \
 2.080814285714286e-08 -0.03333333333333333 \
 2.081607142857143e-08 -0.03333333333333333 \
 2.081707142857143e-08 -0.03333333333333333 \
 2.0825e-08 -0.03333333333333333 \
 2.0826e-08 0.03333333333333333 \
 2.083392857142857e-08 0.03333333333333333 \
 2.083492857142857e-08 0.1 \
 2.084285714285714e-08 0.1 \
 2.084385714285714e-08 0.1 \
 2.085178571428571e-08 0.1 \
 2.085278571428571e-08 0.03333333333333333 \
 2.086071428571428e-08 0.03333333333333333 \
 2.086171428571428e-08 0.03333333333333333 \
 2.086964285714285e-08 0.03333333333333333 \
 2.087064285714286e-08 -0.03333333333333333 \
 2.087857142857143e-08 -0.03333333333333333 \
 2.087957142857143e-08 0.03333333333333333 \
 2.08875e-08 0.03333333333333333 \
 2.08885e-08 0.1 \
 2.089642857142857e-08 0.1 \
 2.089742857142857e-08 0.1 \
 2.090535714285714e-08 0.1 \
 2.090635714285714e-08 -0.03333333333333333 \
 2.091428571428571e-08 -0.03333333333333333 \
 2.091528571428571e-08 0.03333333333333333 \
 2.092321428571429e-08 0.03333333333333333 \
 2.092421428571429e-08 0.03333333333333333 \
 2.093214285714286e-08 0.03333333333333333 \
 2.093314285714286e-08 0.1 \
 2.094107142857143e-08 0.1 \
 2.094207142857143e-08 -0.1 \
 2.095e-08 -0.1 \
 2.0951e-08 0.03333333333333333 \
 2.095892857142857e-08 0.03333333333333333 \
 2.095992857142857e-08 0.03333333333333333 \
 2.096785714285714e-08 0.03333333333333333 \
 2.096885714285714e-08 -0.1 \
 2.097678571428571e-08 -0.1 \
 2.097778571428571e-08 0.03333333333333333 \
 2.098571428571428e-08 0.03333333333333333 \
 2.098671428571428e-08 -0.1 \
 2.099464285714286e-08 -0.1 \
 2.099564285714286e-08 0.03333333333333333 \
 2.100357142857143e-08 0.03333333333333333 \
 2.100457142857143e-08 -0.1 \
 2.10125e-08 -0.1 \
 2.10135e-08 -0.1 \
 2.102142857142857e-08 -0.1 \
 2.102242857142857e-08 -0.1 \
 2.103035714285714e-08 -0.1 \
 2.103135714285714e-08 0.03333333333333333 \
 2.103928571428571e-08 0.03333333333333333 \
 2.104028571428571e-08 -0.1 \
 2.104821428571428e-08 -0.1 \
 2.104921428571429e-08 0.1 \
 2.105714285714285e-08 0.1 \
 2.105814285714286e-08 -0.03333333333333333 \
 2.106607142857143e-08 -0.03333333333333333 \
 2.106707142857143e-08 -0.1 \
 2.1075e-08 -0.1 \
 2.1076e-08 -0.1 \
 2.108392857142857e-08 -0.1 \
 2.108492857142857e-08 -0.1 \
 2.109285714285714e-08 -0.1 \
 2.109385714285714e-08 -0.03333333333333333 \
 2.110178571428571e-08 -0.03333333333333333 \
 2.110278571428571e-08 -0.1 \
 2.111071428571428e-08 -0.1 \
 2.111171428571428e-08 -0.1 \
 2.111964285714286e-08 -0.1 \
 2.112064285714286e-08 0.1 \
 2.112857142857143e-08 0.1 \
 2.112957142857143e-08 -0.03333333333333333 \
 2.11375e-08 -0.03333333333333333 \
 2.11385e-08 0.03333333333333333 \
 2.114642857142857e-08 0.03333333333333333 \
 2.114742857142857e-08 -0.1 \
 2.115535714285714e-08 -0.1 \
 2.115635714285714e-08 -0.1 \
 2.116428571428571e-08 -0.1 \
 2.116528571428571e-08 0.1 \
 2.117321428571428e-08 0.1 \
 2.117421428571429e-08 0.03333333333333333 \
 2.118214285714285e-08 0.03333333333333333 \
 2.118314285714286e-08 0.03333333333333333 \
 2.119107142857143e-08 0.03333333333333333 \
 2.119207142857143e-08 0.03333333333333333 \
 2.12e-08 0.03333333333333333 \
 2.1201e-08 0.1 \
 2.120892857142857e-08 0.1 \
 2.120992857142857e-08 0.03333333333333333 \
 2.121785714285714e-08 0.03333333333333333 \
 2.121885714285714e-08 -0.03333333333333333 \
 2.122678571428571e-08 -0.03333333333333333 \
 2.122778571428571e-08 -0.03333333333333333 \
 2.123571428571429e-08 -0.03333333333333333 \
 2.123671428571429e-08 0.1 \
 2.124464285714286e-08 0.1 \
 2.124564285714286e-08 0.1 \
 2.125357142857143e-08 0.1 \
 2.125457142857143e-08 -0.1 \
 2.12625e-08 -0.1 \
 2.12635e-08 0.1 \
 2.127142857142857e-08 0.1 \
 2.127242857142857e-08 -0.1 \
 2.128035714285714e-08 -0.1 \
 2.128135714285714e-08 -0.03333333333333333 \
 2.128928571428571e-08 -0.03333333333333333 \
 2.129028571428571e-08 0.1 \
 2.129821428571428e-08 0.1 \
 2.129921428571428e-08 0.1 \
 2.130714285714285e-08 0.1 \
 2.130814285714285e-08 -0.1 \
 2.131607142857143e-08 -0.1 \
 2.131707142857143e-08 0.1 \
 2.1325e-08 0.1 \
 2.1326e-08 0.1 \
 2.133392857142857e-08 0.1 \
 2.133492857142857e-08 0.03333333333333333 \
 2.134285714285714e-08 0.03333333333333333 \
 2.134385714285714e-08 -0.1 \
 2.135178571428571e-08 -0.1 \
 2.135278571428571e-08 0.1 \
 2.136071428571428e-08 0.1 \
 2.136171428571429e-08 -0.1 \
 2.136964285714286e-08 -0.1 \
 2.137064285714286e-08 -0.1 \
 2.137857142857143e-08 -0.1 \
 2.137957142857143e-08 0.1 \
 2.13875e-08 0.1 \
 2.13885e-08 0.03333333333333333 \
 2.139642857142857e-08 0.03333333333333333 \
 2.139742857142857e-08 0.03333333333333333 \
 2.140535714285714e-08 0.03333333333333333 \
 2.140635714285714e-08 -0.03333333333333333 \
 2.141428571428571e-08 -0.03333333333333333 \
 2.141528571428571e-08 -0.1 \
 2.142321428571428e-08 -0.1 \
 2.142421428571428e-08 0.1 \
 2.143214285714286e-08 0.1 \
 2.143314285714286e-08 -0.1 \
 2.144107142857143e-08 -0.1 \
 2.144207142857143e-08 0.1 \
 2.145e-08 0.1 \
 2.1451e-08 0.1 \
 2.145892857142857e-08 0.1 \
 2.145992857142857e-08 -0.1 \
 2.146785714285714e-08 -0.1 \
 2.146885714285714e-08 -0.1 \
 2.147678571428571e-08 -0.1 \
 2.147778571428571e-08 0.03333333333333333 \
 2.148571428571428e-08 0.03333333333333333 \
 2.148671428571429e-08 -0.03333333333333333 \
 2.149464285714285e-08 -0.03333333333333333 \
 2.149564285714286e-08 0.1 \
 2.150357142857143e-08 0.1 \
 2.150457142857143e-08 0.03333333333333333 \
 2.15125e-08 0.03333333333333333 \
 2.15135e-08 0.1 \
 2.152142857142857e-08 0.1 \
 2.152242857142857e-08 0.1 \
 2.153035714285714e-08 0.1 \
 2.153135714285714e-08 -0.03333333333333333 \
 2.153928571428571e-08 -0.03333333333333333 \
 2.154028571428571e-08 -0.03333333333333333 \
 2.154821428571428e-08 -0.03333333333333333 \
 2.154921428571428e-08 -0.1 \
 2.155714285714286e-08 -0.1 \
 2.155814285714286e-08 0.1 \
 2.156607142857143e-08 0.1 \
 2.156707142857143e-08 0.03333333333333333 \
 2.1575e-08 0.03333333333333333 \
 2.1576e-08 -0.03333333333333333 \
 2.158392857142857e-08 -0.03333333333333333 \
 2.158492857142857e-08 -0.1 \
 2.159285714285714e-08 -0.1 \
 2.159385714285714e-08 -0.03333333333333333 \
 2.160178571428571e-08 -0.03333333333333333 \
 2.160278571428571e-08 0.03333333333333333 \
 2.161071428571428e-08 0.03333333333333333 \
 2.161171428571428e-08 -0.03333333333333333 \
 2.161964285714285e-08 -0.03333333333333333 \
 2.162064285714286e-08 0.03333333333333333 \
 2.162857142857143e-08 0.03333333333333333 \
 2.162957142857143e-08 -0.1 \
 2.16375e-08 -0.1 \
 2.16385e-08 -0.1 \
 2.164642857142857e-08 -0.1 \
 2.164742857142857e-08 -0.1 \
 2.165535714285714e-08 -0.1 \
 2.165635714285714e-08 0.1 \
 2.166428571428571e-08 0.1 \
 2.166528571428571e-08 0.1 \
 2.167321428571429e-08 0.1 \
 2.167421428571429e-08 -0.1 \
 2.168214285714286e-08 -0.1 \
 2.168314285714286e-08 -0.1 \
 2.169107142857143e-08 -0.1 \
 2.169207142857143e-08 -0.1 \
 2.17e-08 -0.1 \
 2.1701e-08 -0.1 \
 2.170892857142857e-08 -0.1 \
 2.170992857142857e-08 -0.1 \
 2.171785714285714e-08 -0.1 \
 2.171885714285714e-08 0.03333333333333333 \
 2.172678571428571e-08 0.03333333333333333 \
 2.172778571428571e-08 -0.03333333333333333 \
 2.173571428571428e-08 -0.03333333333333333 \
 2.173671428571428e-08 0.03333333333333333 \
 2.174464285714286e-08 0.03333333333333333 \
 2.174564285714286e-08 0.1 \
 2.175357142857143e-08 0.1 \
 2.175457142857143e-08 0.1 \
 2.17625e-08 0.1 \
 2.17635e-08 -0.03333333333333333 \
 2.177142857142857e-08 -0.03333333333333333 \
 2.177242857142857e-08 -0.1 \
 2.178035714285714e-08 -0.1 \
 2.178135714285714e-08 0.1 \
 2.178928571428571e-08 0.1 \
 2.179028571428571e-08 0.03333333333333333 \
 2.179821428571428e-08 0.03333333333333333 \
 2.179921428571429e-08 0.1 \
 2.180714285714285e-08 0.1 \
 2.180814285714286e-08 0.03333333333333333 \
 2.181607142857143e-08 0.03333333333333333 \
 2.181707142857143e-08 -0.03333333333333333 \
 2.1825e-08 -0.03333333333333333 \
 2.1826e-08 0.03333333333333333 \
 2.183392857142857e-08 0.03333333333333333 \
 2.183492857142857e-08 -0.1 \
 2.184285714285714e-08 -0.1 \
 2.184385714285714e-08 -0.03333333333333333 \
 2.185178571428571e-08 -0.03333333333333333 \
 2.185278571428571e-08 -0.03333333333333333 \
 2.186071428571428e-08 -0.03333333333333333 \
 2.186171428571428e-08 0.1 \
 2.186964285714286e-08 0.1 \
 2.187064285714286e-08 -0.03333333333333333 \
 2.187857142857143e-08 -0.03333333333333333 \
 2.187957142857143e-08 0.03333333333333333 \
 2.18875e-08 0.03333333333333333 \
 2.18885e-08 -0.03333333333333333 \
 2.189642857142857e-08 -0.03333333333333333 \
 2.189742857142857e-08 -0.03333333333333333 \
 2.190535714285714e-08 -0.03333333333333333 \
 2.190635714285714e-08 -0.03333333333333333 \
 ]
CHR1p (PAM4_src_p CH1_p) resistor r=100
CHC1p (CH1_p X_cm) capacitor c=8.526157665637249e-14
CHB1p (CHB_p X_cm CH1_p X_cm) vcvs gain=1
CHR2p (CHB_p CH2_p) resistor r=100
CHC2p (CH2_p X_cm) capacitor c=8.526157665637249e-14
CHB2p (X_ip X_cm CH2_p X_cm) vcvs gain=1
PAM4Vm (PAM4_src_m X_cm) vsource type=pwl wave=[ \
 0 0.03333333333333333 \
 2.089285714285714e-10 0.03333333333333333 \
 2.099285714285714e-10 -0.1 \
 2.178571428571429e-10 -0.1 \
 2.188571428571429e-10 0.03333333333333333 \
 2.267857142857143e-10 0.03333333333333333 \
 2.277857142857143e-10 -0.1 \
 2.357142857142857e-10 -0.1 \
 2.367142857142857e-10 -0.1 \
 2.446428571428572e-10 -0.1 \
 2.456428571428572e-10 -0.1 \
 2.535714285714286e-10 -0.1 \
 2.545714285714286e-10 -0.03333333333333333 \
 2.625e-10 -0.03333333333333333 \
 2.635e-10 0.1 \
 2.714285714285714e-10 0.1 \
 2.724285714285714e-10 -0.1 \
 2.803571428571429e-10 -0.1 \
 2.813571428571429e-10 -0.03333333333333333 \
 2.892857142857143e-10 -0.03333333333333333 \
 2.902857142857143e-10 -0.1 \
 2.982142857142857e-10 -0.1 \
 2.992142857142857e-10 0.1 \
 3.071428571428571e-10 0.1 \
 3.081428571428571e-10 0.03333333333333333 \
 3.160714285714286e-10 0.03333333333333333 \
 3.170714285714286e-10 -0.1 \
 3.25e-10 -0.1 \
 3.26e-10 -0.1 \
 3.339285714285715e-10 -0.1 \
 3.349285714285715e-10 -0.1 \
 3.428571428571429e-10 -0.1 \
 3.438571428571429e-10 -0.1 \
 3.517857142857143e-10 -0.1 \
 3.527857142857143e-10 -0.1 \
 3.607142857142857e-10 -0.1 \
 3.617142857142857e-10 -0.1 \
 3.696428571428572e-10 -0.1 \
 3.706428571428572e-10 -0.1 \
 3.785714285714286e-10 -0.1 \
 3.795714285714286e-10 0.03333333333333333 \
 3.875e-10 0.03333333333333333 \
 3.885e-10 0.03333333333333333 \
 3.964285714285714e-10 0.03333333333333333 \
 3.974285714285714e-10 0.03333333333333333 \
 4.053571428571429e-10 0.03333333333333333 \
 4.063571428571428e-10 0.1 \
 4.142857142857143e-10 0.1 \
 4.152857142857143e-10 0.1 \
 4.232142857142858e-10 0.1 \
 4.242142857142857e-10 -0.1 \
 4.321428571428571e-10 -0.1 \
 4.331428571428571e-10 -0.03333333333333333 \
 4.410714285714285e-10 -0.03333333333333333 \
 4.420714285714285e-10 -0.03333333333333333 \
 4.5e-10 -0.03333333333333333 \
 4.51e-10 -0.1 \
 4.589285714285714e-10 -0.1 \
 4.599285714285714e-10 -0.03333333333333333 \
 4.678571428571429e-10 -0.03333333333333333 \
 4.688571428571429e-10 0.03333333333333333 \
 4.767857142857142e-10 0.03333333333333333 \
 4.777857142857142e-10 0.1 \
 4.857142857142857e-10 0.1 \
 4.867142857142857e-10 -0.03333333333333333 \
 4.946428571428571e-10 -0.03333333333333333 \
 4.956428571428571e-10 -0.03333333333333333 \
 5.035714285714286e-10 -0.03333333333333333 \
 5.045714285714286e-10 -0.1 \
 5.125e-10 -0.1 \
 5.135e-10 0.03333333333333333 \
 5.214285714285714e-10 0.03333333333333333 \
 5.224285714285714e-10 0.03333333333333333 \
 5.303571428571428e-10 0.03333333333333333 \
 5.313571428571428e-10 -0.03333333333333333 \
 5.392857142857143e-10 -0.03333333333333333 \
 5.402857142857143e-10 -0.1 \
 5.482142857142857e-10 -0.1 \
 5.492142857142857e-10 -0.03333333333333333 \
 5.571428571428572e-10 -0.03333333333333333 \
 5.581428571428572e-10 0.1 \
 5.660714285714285e-10 0.1 \
 5.670714285714285e-10 -0.03333333333333333 \
 5.75e-10 -0.03333333333333333 \
 5.76e-10 -0.1 \
 5.839285714285714e-10 -0.1 \
 5.849285714285714e-10 0.03333333333333333 \
 5.928571428571429e-10 0.03333333333333333 \
 5.938571428571429e-10 -0.03333333333333333 \
 6.017857142857143e-10 -0.03333333333333333 \
 6.027857142857143e-10 -0.03333333333333333 \
 6.107142857142857e-10 -0.03333333333333333 \
 6.117142857142857e-10 0.03333333333333333 \
 6.196428571428571e-10 0.03333333333333333 \
 6.206428571428571e-10 0.1 \
 6.285714285714286e-10 0.1 \
 6.295714285714286e-10 -0.03333333333333333 \
 6.375e-10 -0.03333333333333333 \
 6.385e-10 0.03333333333333333 \
 6.464285714285715e-10 0.03333333333333333 \
 6.474285714285715e-10 -0.1 \
 6.553571428571428e-10 -0.1 \
 6.563571428571428e-10 0.1 \
 6.642857142857143e-10 0.1 \
 6.652857142857143e-10 0.03333333333333333 \
 6.732142857142857e-10 0.03333333333333333 \
 6.742142857142857e-10 0.03333333333333333 \
 6.821428571428572e-10 0.03333333333333333 \
 6.831428571428572e-10 0.1 \
 6.910714285714286e-10 0.1 \
 6.920714285714286e-10 0.03333333333333333 \
 7.000000000000001e-10 0.03333333333333333 \
 7.010000000000001e-10 -0.03333333333333333 \
 7.089285714285714e-10 -0.03333333333333333 \
 7.099285714285714e-10 0.1 \
 7.178571428571429e-10 0.1 \
 7.188571428571429e-10 -0.1 \
 7.267857142857143e-10 -0.1 \
 7.277857142857143e-10 0.1 \
 7.357142857142858e-10 0.1 \
 7.367142857142858e-10 -0.1 \
 7.446428571428572e-10 -0.1 \
 7.456428571428572e-10 -0.03333333333333333 \
 7.535714285714286e-10 -0.03333333333333333 \
 7.545714285714286e-10 0.03333333333333333 \
 7.625e-10 0.03333333333333333 \
 7.635e-10 0.03333333333333333 \
 7.714285714285715e-10 0.03333333333333333 \
 7.724285714285714e-10 0.1 \
 7.803571428571429e-10 0.1 \
 7.813571428571429e-10 -0.03333333333333333 \
 7.892857142857144e-10 -0.03333333333333333 \
 7.902857142857143e-10 0.03333333333333333 \
 7.982142857142857e-10 0.03333333333333333 \
 7.992142857142857e-10 0.1 \
 8.071428571428571e-10 0.1 \
 8.081428571428571e-10 -0.03333333333333333 \
 8.160714285714286e-10 -0.03333333333333333 \
 8.170714285714286e-10 0.1 \
 8.25e-10 0.1 \
 8.26e-10 0.1 \
 8.339285714285715e-10 0.1 \
 8.349285714285715e-10 -0.03333333333333333 \
 8.428571428571428e-10 -0.03333333333333333 \
 8.438571428571428e-10 -0.1 \
 8.517857142857143e-10 -0.1 \
 8.527857142857143e-10 -0.1 \
 8.607142857142857e-10 -0.1 \
 8.617142857142857e-10 -0.1 \
 8.696428571428572e-10 -0.1 \
 8.706428571428572e-10 0.03333333333333333 \
 8.785714285714286e-10 0.03333333333333333 \
 8.795714285714286e-10 -0.1 \
 8.875e-10 -0.1 \
 8.885e-10 -0.03333333333333333 \
 8.964285714285714e-10 -0.03333333333333333 \
 8.974285714285714e-10 -0.1 \
 9.053571428571429e-10 -0.1 \
 9.063571428571429e-10 0.1 \
 9.142857142857143e-10 0.1 \
 9.152857142857143e-10 0.1 \
 9.232142857142858e-10 0.1 \
 9.242142857142858e-10 0.1 \
 9.321428571428571e-10 0.1 \
 9.331428571428572e-10 -0.1 \
 9.410714285714286e-10 -0.1 \
 9.420714285714287e-10 0.03333333333333333 \
 9.5e-10 0.03333333333333333 \
 9.510000000000001e-10 -0.1 \
 9.589285714285715e-10 -0.1 \
 9.599285714285716e-10 -0.03333333333333333 \
 9.678571428571429e-10 -0.03333333333333333 \
 9.68857142857143e-10 0.1 \
 9.767857142857142e-10 0.1 \
 9.777857142857143e-10 -0.03333333333333333 \
 9.857142857142856e-10 -0.03333333333333333 \
 9.867142857142857e-10 -0.03333333333333333 \
 9.946428571428571e-10 -0.03333333333333333 \
 9.956428571428572e-10 0.1 \
 1.003571428571429e-09 0.1 \
 1.004571428571429e-09 -0.1 \
 1.0125e-09 -0.1 \
 1.0135e-09 0.03333333333333333 \
 1.021428571428571e-09 0.03333333333333333 \
 1.022428571428572e-09 0.1 \
 1.030357142857143e-09 0.1 \
 1.031357142857143e-09 -0.03333333333333333 \
 1.039285714285714e-09 -0.03333333333333333 \
 1.040285714285714e-09 0.1 \
 1.048214285714286e-09 0.1 \
 1.049214285714286e-09 -0.1 \
 1.057142857142857e-09 -0.1 \
 1.058142857142857e-09 0.1 \
 1.066071428571428e-09 0.1 \
 1.067071428571429e-09 -0.1 \
 1.075e-09 -0.1 \
 1.076e-09 -0.1 \
 1.083928571428571e-09 -0.1 \
 1.084928571428571e-09 -0.1 \
 1.092857142857143e-09 -0.1 \
 1.093857142857143e-09 -0.03333333333333333 \
 1.101785714285714e-09 -0.03333333333333333 \
 1.102785714285714e-09 -0.03333333333333333 \
 1.110714285714286e-09 -0.03333333333333333 \
 1.111714285714286e-09 0.03333333333333333 \
 1.119642857142857e-09 0.03333333333333333 \
 1.120642857142857e-09 0.1 \
 1.128571428571429e-09 0.1 \
 1.129571428571429e-09 -0.03333333333333333 \
 1.1375e-09 -0.03333333333333333 \
 1.1385e-09 -0.1 \
 1.146428571428571e-09 -0.1 \
 1.147428571428571e-09 0.03333333333333333 \
 1.155357142857143e-09 0.03333333333333333 \
 1.156357142857143e-09 -0.03333333333333333 \
 1.164285714285714e-09 -0.03333333333333333 \
 1.165285714285714e-09 -0.03333333333333333 \
 1.173214285714286e-09 -0.03333333333333333 \
 1.174214285714286e-09 0.03333333333333333 \
 1.182142857142857e-09 0.03333333333333333 \
 1.183142857142857e-09 -0.03333333333333333 \
 1.191071428571429e-09 -0.03333333333333333 \
 1.192071428571429e-09 -0.1 \
 1.2e-09 -0.1 \
 1.201e-09 0.1 \
 1.208928571428571e-09 0.1 \
 1.209928571428572e-09 0.03333333333333333 \
 1.217857142857143e-09 0.03333333333333333 \
 1.218857142857143e-09 -0.03333333333333333 \
 1.226785714285714e-09 -0.03333333333333333 \
 1.227785714285714e-09 -0.1 \
 1.235714285714286e-09 -0.1 \
 1.236714285714286e-09 -0.03333333333333333 \
 1.244642857142857e-09 -0.03333333333333333 \
 1.245642857142857e-09 -0.03333333333333333 \
 1.253571428571428e-09 -0.03333333333333333 \
 1.254571428571429e-09 -0.1 \
 1.2625e-09 -0.1 \
 1.2635e-09 -0.03333333333333333 \
 1.271428571428571e-09 -0.03333333333333333 \
 1.272428571428571e-09 -0.1 \
 1.280357142857143e-09 -0.1 \
 1.281357142857143e-09 -0.1 \
 1.289285714285714e-09 -0.1 \
 1.290285714285714e-09 0.1 \
 1.298214285714286e-09 0.1 \
 1.299214285714286e-09 -0.1 \
 1.307142857142857e-09 -0.1 \
 1.308142857142857e-09 0.03333333333333333 \
 1.316071428571428e-09 0.03333333333333333 \
 1.317071428571429e-09 -0.03333333333333333 \
 1.325e-09 -0.03333333333333333 \
 1.326e-09 -0.1 \
 1.333928571428571e-09 -0.1 \
 1.334928571428571e-09 -0.1 \
 1.342857142857143e-09 -0.1 \
 1.343857142857143e-09 0.03333333333333333 \
 1.351785714285714e-09 0.03333333333333333 \
 1.352785714285714e-09 -0.03333333333333333 \
 1.360714285714286e-09 -0.03333333333333333 \
 1.361714285714286e-09 0.03333333333333333 \
 1.369642857142857e-09 0.03333333333333333 \
 1.370642857142857e-09 0.03333333333333333 \
 1.378571428571429e-09 0.03333333333333333 \
 1.379571428571429e-09 -0.1 \
 1.3875e-09 -0.1 \
 1.3885e-09 -0.03333333333333333 \
 1.396428571428571e-09 -0.03333333333333333 \
 1.397428571428571e-09 -0.03333333333333333 \
 1.405357142857143e-09 -0.03333333333333333 \
 1.406357142857143e-09 0.03333333333333333 \
 1.414285714285714e-09 0.03333333333333333 \
 1.415285714285714e-09 0.1 \
 1.423214285714286e-09 0.1 \
 1.424214285714286e-09 -0.1 \
 1.432142857142857e-09 -0.1 \
 1.433142857142857e-09 -0.1 \
 1.441071428571429e-09 -0.1 \
 1.442071428571429e-09 -0.1 \
 1.45e-09 -0.1 \
 1.451e-09 -0.1 \
 1.458928571428571e-09 -0.1 \
 1.459928571428572e-09 0.03333333333333333 \
 1.467857142857143e-09 0.03333333333333333 \
 1.468857142857143e-09 0.03333333333333333 \
 1.476785714285714e-09 0.03333333333333333 \
 1.477785714285714e-09 0.1 \
 1.485714285714286e-09 0.1 \
 1.486714285714286e-09 0.03333333333333333 \
 1.494642857142857e-09 0.03333333333333333 \
 1.495642857142857e-09 0.1 \
 1.503571428571428e-09 0.1 \
 1.504571428571429e-09 0.1 \
 1.5125e-09 0.1 \
 1.5135e-09 0.1 \
 1.521428571428571e-09 0.1 \
 1.522428571428571e-09 0.1 \
 1.530357142857143e-09 0.1 \
 1.531357142857143e-09 0.03333333333333333 \
 1.539285714285714e-09 0.03333333333333333 \
 1.540285714285714e-09 -0.1 \
 1.548214285714286e-09 -0.1 \
 1.549214285714286e-09 -0.1 \
 1.557142857142857e-09 -0.1 \
 1.558142857142857e-09 -0.1 \
 1.566071428571428e-09 -0.1 \
 1.567071428571428e-09 0.1 \
 1.575e-09 0.1 \
 1.576e-09 0.03333333333333333 \
 1.583928571428571e-09 0.03333333333333333 \
 1.584928571428571e-09 -0.1 \
 1.592857142857143e-09 -0.1 \
 1.593857142857143e-09 0.03333333333333333 \
 1.601785714285714e-09 0.03333333333333333 \
 1.602785714285714e-09 -0.03333333333333333 \
 1.610714285714286e-09 -0.03333333333333333 \
 1.611714285714286e-09 0.03333333333333333 \
 1.619642857142857e-09 0.03333333333333333 \
 1.620642857142857e-09 -0.1 \
 1.628571428571429e-09 -0.1 \
 1.629571428571429e-09 -0.1 \
 1.6375e-09 -0.1 \
 1.6385e-09 0.1 \
 1.646428571428571e-09 0.1 \
 1.647428571428572e-09 -0.1 \
 1.655357142857143e-09 -0.1 \
 1.656357142857143e-09 -0.03333333333333333 \
 1.664285714285714e-09 -0.03333333333333333 \
 1.665285714285714e-09 -0.03333333333333333 \
 1.673214285714286e-09 -0.03333333333333333 \
 1.674214285714286e-09 0.1 \
 1.682142857142857e-09 0.1 \
 1.683142857142857e-09 0.1 \
 1.691071428571428e-09 0.1 \
 1.692071428571429e-09 -0.1 \
 1.7e-09 -0.1 \
 1.701e-09 -0.03333333333333333 \
 1.708928571428571e-09 -0.03333333333333333 \
 1.709928571428571e-09 -0.1 \
 1.717857142857143e-09 -0.1 \
 1.718857142857143e-09 -0.03333333333333333 \
 1.726785714285714e-09 -0.03333333333333333 \
 1.727785714285714e-09 0.03333333333333333 \
 1.735714285714286e-09 0.03333333333333333 \
 1.736714285714286e-09 -0.03333333333333333 \
 1.744642857142857e-09 -0.03333333333333333 \
 1.745642857142857e-09 0.03333333333333333 \
 1.753571428571428e-09 0.03333333333333333 \
 1.754571428571429e-09 0.1 \
 1.7625e-09 0.1 \
 1.7635e-09 0.1 \
 1.771428571428571e-09 0.1 \
 1.772428571428571e-09 -0.1 \
 1.780357142857143e-09 -0.1 \
 1.781357142857143e-09 -0.03333333333333333 \
 1.789285714285714e-09 -0.03333333333333333 \
 1.790285714285714e-09 0.03333333333333333 \
 1.798214285714286e-09 0.03333333333333333 \
 1.799214285714286e-09 -0.03333333333333333 \
 1.807142857142857e-09 -0.03333333333333333 \
 1.808142857142857e-09 -0.03333333333333333 \
 1.816071428571429e-09 -0.03333333333333333 \
 1.817071428571429e-09 -0.1 \
 1.825e-09 -0.1 \
 1.826e-09 -0.1 \
 1.833928571428571e-09 -0.1 \
 1.834928571428571e-09 -0.1 \
 1.842857142857143e-09 -0.1 \
 1.843857142857143e-09 -0.1 \
 1.851785714285714e-09 -0.1 \
 1.852785714285714e-09 -0.1 \
 1.860714285714286e-09 -0.1 \
 1.861714285714286e-09 0.1 \
 1.869642857142857e-09 0.1 \
 1.870642857142857e-09 0.03333333333333333 \
 1.878571428571428e-09 0.03333333333333333 \
 1.879571428571428e-09 -0.03333333333333333 \
 1.8875e-09 -0.03333333333333333 \
 1.8885e-09 0.1 \
 1.896428571428571e-09 0.1 \
 1.897428571428571e-09 -0.1 \
 1.905357142857143e-09 -0.1 \
 1.906357142857143e-09 -0.1 \
 1.914285714285714e-09 -0.1 \
 1.915285714285714e-09 0.03333333333333333 \
 1.923214285714286e-09 0.03333333333333333 \
 1.924214285714286e-09 -0.03333333333333333 \
 1.932142857142857e-09 -0.03333333333333333 \
 1.933142857142857e-09 0.1 \
 1.941071428571429e-09 0.1 \
 1.942071428571429e-09 0.1 \
 1.95e-09 0.1 \
 1.951e-09 -0.1 \
 1.958928571428572e-09 -0.1 \
 1.959928571428571e-09 -0.1 \
 1.967857142857143e-09 -0.1 \
 1.968857142857143e-09 -0.1 \
 1.976785714285714e-09 -0.1 \
 1.977785714285714e-09 -0.1 \
 1.985714285714286e-09 -0.1 \
 1.986714285714286e-09 -0.1 \
 1.994642857142857e-09 -0.1 \
 1.995642857142857e-09 -0.03333333333333333 \
 2.003571428571428e-09 -0.03333333333333333 \
 2.004571428571428e-09 0.03333333333333333 \
 2.0125e-09 0.03333333333333333 \
 2.0135e-09 0.1 \
 2.021428571428571e-09 0.1 \
 2.022428571428571e-09 0.03333333333333333 \
 2.030357142857143e-09 0.03333333333333333 \
 2.031357142857143e-09 0.1 \
 2.039285714285714e-09 0.1 \
 2.040285714285714e-09 0.1 \
 2.048214285714286e-09 0.1 \
 2.049214285714286e-09 0.1 \
 2.057142857142857e-09 0.1 \
 2.058142857142857e-09 0.1 \
 2.066071428571429e-09 0.1 \
 2.067071428571428e-09 -0.1 \
 2.075e-09 -0.1 \
 2.076e-09 -0.03333333333333333 \
 2.083928571428571e-09 -0.03333333333333333 \
 2.084928571428571e-09 -0.1 \
 2.092857142857143e-09 -0.1 \
 2.093857142857143e-09 0.1 \
 2.101785714285714e-09 0.1 \
 2.102785714285714e-09 0.03333333333333333 \
 2.110714285714286e-09 0.03333333333333333 \
 2.111714285714286e-09 -0.1 \
 2.119642857142857e-09 -0.1 \
 2.120642857142857e-09 0.03333333333333333 \
 2.128571428571429e-09 0.03333333333333333 \
 2.129571428571429e-09 0.1 \
 2.1375e-09 0.1 \
 2.1385e-09 -0.03333333333333333 \
 2.146428571428572e-09 -0.03333333333333333 \
 2.147428571428571e-09 -0.1 \
 2.155357142857143e-09 -0.1 \
 2.156357142857143e-09 0.1 \
 2.164285714285714e-09 0.1 \
 2.165285714285714e-09 -0.03333333333333333 \
 2.173214285714286e-09 -0.03333333333333333 \
 2.174214285714286e-09 -0.03333333333333333 \
 2.182142857142857e-09 -0.03333333333333333 \
 2.183142857142857e-09 -0.1 \
 2.191071428571429e-09 -0.1 \
 2.192071428571429e-09 0.1 \
 2.2e-09 0.1 \
 2.201e-09 -0.03333333333333333 \
 2.208928571428572e-09 -0.03333333333333333 \
 2.209928571428572e-09 0.03333333333333333 \
 2.217857142857143e-09 0.03333333333333333 \
 2.218857142857143e-09 0.03333333333333333 \
 2.226785714285714e-09 0.03333333333333333 \
 2.227785714285714e-09 0.1 \
 2.235714285714286e-09 0.1 \
 2.236714285714286e-09 -0.1 \
 2.244642857142857e-09 -0.1 \
 2.245642857142857e-09 0.1 \
 2.253571428571429e-09 0.1 \
 2.254571428571428e-09 -0.03333333333333333 \
 2.2625e-09 -0.03333333333333333 \
 2.2635e-09 0.03333333333333333 \
 2.271428571428571e-09 0.03333333333333333 \
 2.272428571428571e-09 -0.1 \
 2.280357142857143e-09 -0.1 \
 2.281357142857143e-09 -0.03333333333333333 \
 2.289285714285714e-09 -0.03333333333333333 \
 2.290285714285714e-09 -0.1 \
 2.298214285714286e-09 -0.1 \
 2.299214285714286e-09 -0.03333333333333333 \
 2.307142857142857e-09 -0.03333333333333333 \
 2.308142857142857e-09 0.1 \
 2.316071428571429e-09 0.1 \
 2.317071428571429e-09 -0.03333333333333333 \
 2.325e-09 -0.03333333333333333 \
 2.326e-09 -0.1 \
 2.333928571428572e-09 -0.1 \
 2.334928571428571e-09 -0.03333333333333333 \
 2.342857142857143e-09 -0.03333333333333333 \
 2.343857142857143e-09 0.03333333333333333 \
 2.351785714285714e-09 0.03333333333333333 \
 2.352785714285714e-09 0.03333333333333333 \
 2.360714285714286e-09 0.03333333333333333 \
 2.361714285714286e-09 0.1 \
 2.369642857142857e-09 0.1 \
 2.370642857142857e-09 0.1 \
 2.378571428571429e-09 0.1 \
 2.379571428571429e-09 -0.1 \
 2.3875e-09 -0.1 \
 2.3885e-09 -0.1 \
 2.396428571428572e-09 -0.1 \
 2.397428571428572e-09 0.1 \
 2.405357142857143e-09 0.1 \
 2.406357142857143e-09 0.03333333333333333 \
 2.414285714285714e-09 0.03333333333333333 \
 2.415285714285714e-09 -0.03333333333333333 \
 2.423214285714286e-09 -0.03333333333333333 \
 2.424214285714286e-09 0.03333333333333333 \
 2.432142857142857e-09 0.03333333333333333 \
 2.433142857142857e-09 0.1 \
 2.441071428571429e-09 0.1 \
 2.442071428571428e-09 -0.03333333333333333 \
 2.45e-09 -0.03333333333333333 \
 2.451e-09 -0.03333333333333333 \
 2.458928571428571e-09 -0.03333333333333333 \
 2.459928571428571e-09 0.03333333333333333 \
 2.467857142857143e-09 0.03333333333333333 \
 2.468857142857143e-09 0.1 \
 2.476785714285714e-09 0.1 \
 2.477785714285714e-09 -0.03333333333333333 \
 2.485714285714286e-09 -0.03333333333333333 \
 2.486714285714286e-09 -0.1 \
 2.494642857142857e-09 -0.1 \
 2.495642857142857e-09 -0.1 \
 2.503571428571429e-09 -0.1 \
 2.504571428571429e-09 0.03333333333333333 \
 2.5125e-09 0.03333333333333333 \
 2.5135e-09 -0.1 \
 2.521428571428572e-09 -0.1 \
 2.522428571428572e-09 -0.1 \
 2.530357142857143e-09 -0.1 \
 2.531357142857143e-09 0.1 \
 2.539285714285715e-09 0.1 \
 2.540285714285714e-09 0.03333333333333333 \
 2.548214285714286e-09 0.03333333333333333 \
 2.549214285714286e-09 -0.1 \
 2.557142857142857e-09 -0.1 \
 2.558142857142857e-09 0.1 \
 2.566071428571429e-09 0.1 \
 2.567071428571429e-09 -0.1 \
 2.575e-09 -0.1 \
 2.576e-09 0.1 \
 2.583928571428571e-09 0.1 \
 2.584928571428571e-09 -0.1 \
 2.592857142857143e-09 -0.1 \
 2.593857142857143e-09 0.1 \
 2.601785714285714e-09 0.1 \
 2.602785714285714e-09 0.03333333333333333 \
 2.610714285714286e-09 0.03333333333333333 \
 2.611714285714286e-09 0.1 \
 2.619642857142857e-09 0.1 \
 2.620642857142857e-09 -0.1 \
 2.628571428571429e-09 -0.1 \
 2.629571428571428e-09 -0.1 \
 2.6375e-09 -0.1 \
 2.6385e-09 0.03333333333333333 \
 2.646428571428571e-09 0.03333333333333333 \
 2.647428571428571e-09 0.1 \
 2.655357142857143e-09 0.1 \
 2.656357142857143e-09 -0.03333333333333333 \
 2.664285714285714e-09 -0.03333333333333333 \
 2.665285714285714e-09 0.1 \
 2.673214285714286e-09 0.1 \
 2.674214285714286e-09 0.1 \
 2.682142857142857e-09 0.1 \
 2.683142857142857e-09 0.03333333333333333 \
 2.691071428571429e-09 0.03333333333333333 \
 2.692071428571429e-09 -0.03333333333333333 \
 2.7e-09 -0.03333333333333333 \
 2.701e-09 -0.03333333333333333 \
 2.708928571428572e-09 -0.03333333333333333 \
 2.709928571428572e-09 -0.1 \
 2.717857142857143e-09 -0.1 \
 2.718857142857143e-09 0.03333333333333333 \
 2.726785714285715e-09 0.03333333333333333 \
 2.727785714285714e-09 -0.1 \
 2.735714285714286e-09 -0.1 \
 2.736714285714286e-09 0.1 \
 2.744642857142857e-09 0.1 \
 2.745642857142857e-09 0.1 \
 2.753571428571428e-09 0.1 \
 2.754571428571428e-09 -0.1 \
 2.7625e-09 -0.1 \
 2.7635e-09 0.03333333333333333 \
 2.771428571428571e-09 0.03333333333333333 \
 2.772428571428571e-09 0.1 \
 2.780357142857143e-09 0.1 \
 2.781357142857143e-09 -0.03333333333333333 \
 2.789285714285714e-09 -0.03333333333333333 \
 2.790285714285714e-09 0.03333333333333333 \
 2.798214285714286e-09 0.03333333333333333 \
 2.799214285714286e-09 -0.03333333333333333 \
 2.807142857142857e-09 -0.03333333333333333 \
 2.808142857142857e-09 0.03333333333333333 \
 2.816071428571429e-09 0.03333333333333333 \
 2.817071428571429e-09 -0.03333333333333333 \
 2.825e-09 -0.03333333333333333 \
 2.826e-09 0.03333333333333333 \
 2.833928571428572e-09 0.03333333333333333 \
 2.834928571428571e-09 0.03333333333333333 \
 2.842857142857143e-09 0.03333333333333333 \
 2.843857142857143e-09 0.03333333333333333 \
 2.851785714285714e-09 0.03333333333333333 \
 2.852785714285714e-09 -0.1 \
 2.860714285714286e-09 -0.1 \
 2.861714285714286e-09 0.1 \
 2.869642857142857e-09 0.1 \
 2.870642857142857e-09 0.1 \
 2.878571428571429e-09 0.1 \
 2.879571428571429e-09 0.1 \
 2.8875e-09 0.1 \
 2.8885e-09 0.1 \
 2.896428571428572e-09 0.1 \
 2.897428571428572e-09 0.1 \
 2.905357142857143e-09 0.1 \
 2.906357142857143e-09 0.03333333333333333 \
 2.914285714285715e-09 0.03333333333333333 \
 2.915285714285714e-09 0.03333333333333333 \
 2.923214285714286e-09 0.03333333333333333 \
 2.924214285714286e-09 0.03333333333333333 \
 2.932142857142857e-09 0.03333333333333333 \
 2.933142857142857e-09 -0.1 \
 2.941071428571428e-09 -0.1 \
 2.942071428571428e-09 -0.03333333333333333 \
 2.95e-09 -0.03333333333333333 \
 2.951e-09 -0.03333333333333333 \
 2.958928571428571e-09 -0.03333333333333333 \
 2.959928571428571e-09 -0.1 \
 2.967857142857143e-09 -0.1 \
 2.968857142857143e-09 0.1 \
 2.976785714285714e-09 0.1 \
 2.977785714285714e-09 -0.03333333333333333 \
 2.985714285714286e-09 -0.03333333333333333 \
 2.986714285714286e-09 -0.03333333333333333 \
 2.994642857142857e-09 -0.03333333333333333 \
 2.995642857142857e-09 0.03333333333333333 \
 3.003571428571429e-09 0.03333333333333333 \
 3.004571428571429e-09 -0.1 \
 3.0125e-09 -0.1 \
 3.0135e-09 -0.03333333333333333 \
 3.021428571428572e-09 -0.03333333333333333 \
 3.022428571428571e-09 0.1 \
 3.030357142857143e-09 0.1 \
 3.031357142857143e-09 0.03333333333333333 \
 3.039285714285714e-09 0.03333333333333333 \
 3.040285714285714e-09 0.03333333333333333 \
 3.048214285714286e-09 0.03333333333333333 \
 3.049214285714286e-09 0.03333333333333333 \
 3.057142857142857e-09 0.03333333333333333 \
 3.058142857142857e-09 0.1 \
 3.066071428571429e-09 0.1 \
 3.067071428571429e-09 0.03333333333333333 \
 3.075e-09 0.03333333333333333 \
 3.076e-09 0.03333333333333333 \
 3.083928571428572e-09 0.03333333333333333 \
 3.084928571428572e-09 -0.03333333333333333 \
 3.092857142857143e-09 -0.03333333333333333 \
 3.093857142857143e-09 0.1 \
 3.101785714285714e-09 0.1 \
 3.102785714285714e-09 0.03333333333333333 \
 3.110714285714286e-09 0.03333333333333333 \
 3.111714285714286e-09 0.03333333333333333 \
 3.119642857142857e-09 0.03333333333333333 \
 3.120642857142857e-09 0.03333333333333333 \
 3.128571428571429e-09 0.03333333333333333 \
 3.129571428571428e-09 -0.03333333333333333 \
 3.1375e-09 -0.03333333333333333 \
 3.1385e-09 -0.03333333333333333 \
 3.146428571428571e-09 -0.03333333333333333 \
 3.147428571428571e-09 0.03333333333333333 \
 3.155357142857143e-09 0.03333333333333333 \
 3.156357142857143e-09 -0.1 \
 3.164285714285714e-09 -0.1 \
 3.165285714285714e-09 -0.03333333333333333 \
 3.173214285714286e-09 -0.03333333333333333 \
 3.174214285714286e-09 -0.1 \
 3.182142857142857e-09 -0.1 \
 3.183142857142857e-09 0.1 \
 3.191071428571429e-09 0.1 \
 3.192071428571429e-09 -0.1 \
 3.2e-09 -0.1 \
 3.201e-09 0.03333333333333333 \
 3.208928571428572e-09 0.03333333333333333 \
 3.209928571428571e-09 -0.03333333333333333 \
 3.217857142857143e-09 -0.03333333333333333 \
 3.218857142857143e-09 -0.1 \
 3.226785714285714e-09 -0.1 \
 3.227785714285714e-09 -0.03333333333333333 \
 3.235714285714286e-09 -0.03333333333333333 \
 3.236714285714286e-09 0.03333333333333333 \
 3.244642857142857e-09 0.03333333333333333 \
 3.245642857142857e-09 -0.03333333333333333 \
 3.253571428571429e-09 -0.03333333333333333 \
 3.254571428571429e-09 0.03333333333333333 \
 3.2625e-09 0.03333333333333333 \
 3.2635e-09 -0.03333333333333333 \
 3.271428571428572e-09 -0.03333333333333333 \
 3.272428571428572e-09 0.1 \
 3.280357142857143e-09 0.1 \
 3.281357142857143e-09 0.1 \
 3.289285714285714e-09 0.1 \
 3.290285714285714e-09 0.1 \
 3.298214285714286e-09 0.1 \
 3.299214285714286e-09 0.1 \
 3.307142857142857e-09 0.1 \
 3.308142857142857e-09 -0.1 \
 3.316071428571429e-09 -0.1 \
 3.317071428571428e-09 0.03333333333333333 \
 3.325e-09 0.03333333333333333 \
 3.326e-09 0.03333333333333333 \
 3.333928571428571e-09 0.03333333333333333 \
 3.334928571428571e-09 0.1 \
 3.342857142857143e-09 0.1 \
 3.343857142857143e-09 0.03333333333333333 \
 3.351785714285714e-09 0.03333333333333333 \
 3.352785714285714e-09 -0.03333333333333333 \
 3.360714285714286e-09 -0.03333333333333333 \
 3.361714285714286e-09 -0.1 \
 3.369642857142857e-09 -0.1 \
 3.370642857142857e-09 0.03333333333333333 \
 3.378571428571429e-09 0.03333333333333333 \
 3.379571428571429e-09 0.03333333333333333 \
 3.3875e-09 0.03333333333333333 \
 3.3885e-09 -0.1 \
 3.396428571428572e-09 -0.1 \
 3.397428571428571e-09 0.03333333333333333 \
 3.405357142857143e-09 0.03333333333333333 \
 3.406357142857143e-09 0.1 \
 3.414285714285714e-09 0.1 \
 3.415285714285714e-09 -0.1 \
 3.423214285714286e-09 -0.1 \
 3.424214285714286e-09 0.03333333333333333 \
 3.432142857142857e-09 0.03333333333333333 \
 3.433142857142857e-09 0.1 \
 3.441071428571429e-09 0.1 \
 3.442071428571429e-09 0.03333333333333333 \
 3.45e-09 0.03333333333333333 \
 3.451e-09 -0.1 \
 3.458928571428571e-09 -0.1 \
 3.459928571428571e-09 -0.03333333333333333 \
 3.467857142857143e-09 -0.03333333333333333 \
 3.468857142857143e-09 -0.03333333333333333 \
 3.476785714285714e-09 -0.03333333333333333 \
 3.477785714285714e-09 0.1 \
 3.485714285714286e-09 0.1 \
 3.486714285714286e-09 0.03333333333333333 \
 3.494642857142857e-09 0.03333333333333333 \
 3.495642857142857e-09 -0.1 \
 3.503571428571429e-09 -0.1 \
 3.504571428571428e-09 -0.1 \
 3.5125e-09 -0.1 \
 3.5135e-09 -0.03333333333333333 \
 3.521428571428571e-09 -0.03333333333333333 \
 3.522428571428571e-09 0.1 \
 3.530357142857143e-09 0.1 \
 3.531357142857143e-09 -0.1 \
 3.539285714285714e-09 -0.1 \
 3.540285714285714e-09 0.03333333333333333 \
 3.548214285714286e-09 0.03333333333333333 \
 3.549214285714286e-09 -0.1 \
 3.557142857142857e-09 -0.1 \
 3.558142857142857e-09 0.03333333333333333 \
 3.566071428571429e-09 0.03333333333333333 \
 3.567071428571429e-09 -0.1 \
 3.575e-09 -0.1 \
 3.576e-09 0.1 \
 3.583928571428572e-09 0.1 \
 3.584928571428572e-09 0.03333333333333333 \
 3.592857142857143e-09 0.03333333333333333 \
 3.593857142857143e-09 -0.1 \
 3.601785714285715e-09 -0.1 \
 3.602785714285714e-09 0.1 \
 3.610714285714286e-09 0.1 \
 3.611714285714286e-09 0.03333333333333333 \
 3.619642857142857e-09 0.03333333333333333 \
 3.620642857142857e-09 -0.1 \
 3.628571428571428e-09 -0.1 \
 3.629571428571428e-09 0.1 \
 3.6375e-09 0.1 \
 3.6385e-09 0.1 \
 3.646428571428571e-09 0.1 \
 3.647428571428571e-09 -0.1 \
 3.655357142857143e-09 -0.1 \
 3.656357142857143e-09 -0.03333333333333333 \
 3.664285714285714e-09 -0.03333333333333333 \
 3.665285714285714e-09 -0.1 \
 3.673214285714286e-09 -0.1 \
 3.674214285714286e-09 -0.03333333333333333 \
 3.682142857142857e-09 -0.03333333333333333 \
 3.683142857142857e-09 -0.03333333333333333 \
 3.691071428571429e-09 -0.03333333333333333 \
 3.692071428571428e-09 -0.1 \
 3.7e-09 -0.1 \
 3.701e-09 -0.03333333333333333 \
 3.708928571428571e-09 -0.03333333333333333 \
 3.709928571428571e-09 -0.03333333333333333 \
 3.717857142857143e-09 -0.03333333333333333 \
 3.718857142857143e-09 0.1 \
 3.726785714285714e-09 0.1 \
 3.727785714285714e-09 0.1 \
 3.735714285714286e-09 0.1 \
 3.736714285714286e-09 0.1 \
 3.744642857142857e-09 0.1 \
 3.745642857142857e-09 0.03333333333333333 \
 3.753571428571429e-09 0.03333333333333333 \
 3.754571428571429e-09 -0.03333333333333333 \
 3.7625e-09 -0.03333333333333333 \
 3.7635e-09 -0.1 \
 3.771428571428572e-09 -0.1 \
 3.772428571428572e-09 -0.03333333333333333 \
 3.780357142857143e-09 -0.03333333333333333 \
 3.781357142857143e-09 0.1 \
 3.789285714285715e-09 0.1 \
 3.790285714285715e-09 0.03333333333333333 \
 3.798214285714286e-09 0.03333333333333333 \
 3.799214285714286e-09 -0.1 \
 3.807142857142857e-09 -0.1 \
 3.808142857142857e-09 0.03333333333333333 \
 3.816071428571428e-09 0.03333333333333333 \
 3.817071428571429e-09 -0.1 \
 3.825e-09 -0.1 \
 3.826e-09 0.03333333333333333 \
 3.833928571428571e-09 0.03333333333333333 \
 3.834928571428572e-09 0.1 \
 3.842857142857142e-09 0.1 \
 3.843857142857143e-09 0.1 \
 3.851785714285714e-09 0.1 \
 3.852785714285715e-09 0.03333333333333333 \
 3.860714285714285e-09 0.03333333333333333 \
 3.861714285714286e-09 0.1 \
 3.869642857142857e-09 0.1 \
 3.870642857142857e-09 0.1 \
 3.878571428571428e-09 0.1 \
 3.879571428571429e-09 -0.03333333333333333 \
 3.8875e-09 -0.03333333333333333 \
 3.8885e-09 -0.1 \
 3.896428571428571e-09 -0.1 \
 3.897428571428571e-09 -0.1 \
 3.905357142857143e-09 -0.1 \
 3.906357142857143e-09 -0.03333333333333333 \
 3.914285714285714e-09 -0.03333333333333333 \
 3.915285714285714e-09 0.03333333333333333 \
 3.923214285714286e-09 0.03333333333333333 \
 3.924214285714286e-09 -0.03333333333333333 \
 3.932142857142857e-09 -0.03333333333333333 \
 3.933142857142857e-09 -0.03333333333333333 \
 3.941071428571429e-09 -0.03333333333333333 \
 3.942071428571429e-09 0.1 \
 3.95e-09 0.1 \
 3.951e-09 0.1 \
 3.958928571428572e-09 0.1 \
 3.959928571428572e-09 0.03333333333333333 \
 3.967857142857143e-09 0.03333333333333333 \
 3.968857142857143e-09 -0.03333333333333333 \
 3.976785714285715e-09 -0.03333333333333333 \
 3.977785714285715e-09 -0.03333333333333333 \
 3.985714285714286e-09 -0.03333333333333333 \
 3.986714285714286e-09 -0.1 \
 3.994642857142857e-09 -0.1 \
 3.995642857142858e-09 0.03333333333333333 \
 4.003571428571428e-09 0.03333333333333333 \
 4.004571428571429e-09 0.03333333333333333 \
 4.0125e-09 0.03333333333333333 \
 4.013500000000001e-09 -0.03333333333333333 \
 4.021428571428571e-09 -0.03333333333333333 \
 4.022428571428572e-09 0.03333333333333333 \
 4.030357142857143e-09 0.03333333333333333 \
 4.031357142857144e-09 0.1 \
 4.039285714285714e-09 0.1 \
 4.040285714285715e-09 -0.03333333333333333 \
 4.048214285714286e-09 -0.03333333333333333 \
 4.049214285714286e-09 -0.1 \
 4.057142857142857e-09 -0.1 \
 4.058142857142858e-09 0.1 \
 4.066071428571429e-09 0.1 \
 4.067071428571429e-09 0.1 \
 4.075e-09 0.1 \
 4.076e-09 -0.1 \
 4.083928571428571e-09 -0.1 \
 4.084928571428571e-09 0.03333333333333333 \
 4.092857142857143e-09 0.03333333333333333 \
 4.093857142857143e-09 0.03333333333333333 \
 4.101785714285714e-09 0.03333333333333333 \
 4.102785714285714e-09 0.1 \
 4.110714285714286e-09 0.1 \
 4.111714285714286e-09 -0.1 \
 4.119642857142857e-09 -0.1 \
 4.120642857142857e-09 -0.03333333333333333 \
 4.128571428571429e-09 -0.03333333333333333 \
 4.129571428571429e-09 0.1 \
 4.1375e-09 0.1 \
 4.1385e-09 0.1 \
 4.146428571428572e-09 0.1 \
 4.147428571428572e-09 0.03333333333333333 \
 4.155357142857143e-09 0.03333333333333333 \
 4.156357142857143e-09 0.03333333333333333 \
 4.164285714285715e-09 0.03333333333333333 \
 4.165285714285715e-09 -0.03333333333333333 \
 4.173214285714286e-09 -0.03333333333333333 \
 4.174214285714286e-09 -0.03333333333333333 \
 4.182142857142857e-09 -0.03333333333333333 \
 4.183142857142858e-09 -0.1 \
 4.191071428571429e-09 -0.1 \
 4.192071428571429e-09 0.1 \
 4.2e-09 0.1 \
 4.201000000000001e-09 0.03333333333333333 \
 4.208928571428571e-09 0.03333333333333333 \
 4.209928571428572e-09 -0.1 \
 4.217857142857143e-09 -0.1 \
 4.218857142857144e-09 -0.1 \
 4.226785714285714e-09 -0.1 \
 4.227785714285715e-09 -0.1 \
 4.235714285714286e-09 -0.1 \
 4.236714285714286e-09 0.1 \
 4.244642857142857e-09 0.1 \
 4.245642857142858e-09 -0.1 \
 4.253571428571428e-09 -0.1 \
 4.254571428571429e-09 0.03333333333333333 \
 4.2625e-09 0.03333333333333333 \
 4.2635e-09 0.03333333333333333 \
 4.271428571428571e-09 0.03333333333333333 \
 4.272428571428571e-09 0.1 \
 4.280357142857143e-09 0.1 \
 4.281357142857143e-09 -0.03333333333333333 \
 4.289285714285714e-09 -0.03333333333333333 \
 4.290285714285714e-09 -0.03333333333333333 \
 4.298214285714286e-09 -0.03333333333333333 \
 4.299214285714286e-09 0.1 \
 4.307142857142857e-09 0.1 \
 4.308142857142857e-09 -0.03333333333333333 \
 4.316071428571429e-09 -0.03333333333333333 \
 4.317071428571429e-09 -0.1 \
 4.325e-09 -0.1 \
 4.326e-09 0.03333333333333333 \
 4.333928571428572e-09 0.03333333333333333 \
 4.334928571428572e-09 -0.1 \
 4.342857142857143e-09 -0.1 \
 4.343857142857143e-09 0.03333333333333333 \
 4.351785714285715e-09 0.03333333333333333 \
 4.352785714285715e-09 0.03333333333333333 \
 4.360714285714286e-09 0.03333333333333333 \
 4.361714285714286e-09 0.1 \
 4.369642857142858e-09 0.1 \
 4.370642857142858e-09 -0.03333333333333333 \
 4.378571428571429e-09 -0.03333333333333333 \
 4.379571428571429e-09 0.1 \
 4.3875e-09 0.1 \
 4.388500000000001e-09 -0.03333333333333333 \
 4.396428571428571e-09 -0.03333333333333333 \
 4.397428571428572e-09 -0.1 \
 4.405357142857143e-09 -0.1 \
 4.406357142857144e-09 -0.03333333333333333 \
 4.414285714285714e-09 -0.03333333333333333 \
 4.415285714285715e-09 0.1 \
 4.423214285714285e-09 0.1 \
 4.424214285714286e-09 0.1 \
 4.432142857142857e-09 0.1 \
 4.433142857142858e-09 -0.1 \
 4.441071428571428e-09 -0.1 \
 4.442071428571429e-09 0.03333333333333333 \
 4.45e-09 0.03333333333333333 \
 4.451e-09 -0.03333333333333333 \
 4.458928571428571e-09 -0.03333333333333333 \
 4.459928571428571e-09 -0.03333333333333333 \
 4.467857142857143e-09 -0.03333333333333333 \
 4.468857142857143e-09 -0.1 \
 4.476785714285714e-09 -0.1 \
 4.477785714285714e-09 -0.1 \
 4.485714285714286e-09 -0.1 \
 4.486714285714286e-09 -0.1 \
 4.494642857142857e-09 -0.1 \
 4.495642857142857e-09 -0.1 \
 4.503571428571429e-09 -0.1 \
 4.504571428571429e-09 -0.1 \
 4.5125e-09 -0.1 \
 4.5135e-09 0.1 \
 4.521428571428572e-09 0.1 \
 4.522428571428572e-09 0.03333333333333333 \
 4.530357142857143e-09 0.03333333333333333 \
 4.531357142857143e-09 0.03333333333333333 \
 4.539285714285715e-09 0.03333333333333333 \
 4.540285714285715e-09 0.1 \
 4.548214285714286e-09 0.1 \
 4.549214285714286e-09 -0.1 \
 4.557142857142858e-09 -0.1 \
 4.558142857142858e-09 0.03333333333333333 \
 4.566071428571429e-09 0.03333333333333333 \
 4.567071428571429e-09 0.1 \
 4.575e-09 0.1 \
 4.576000000000001e-09 0.03333333333333333 \
 4.583928571428571e-09 0.03333333333333333 \
 4.584928571428572e-09 -0.1 \
 4.592857142857143e-09 -0.1 \
 4.593857142857144e-09 0.1 \
 4.601785714285714e-09 0.1 \
 4.602785714285715e-09 0.03333333333333333 \
 4.610714285714285e-09 0.03333333333333333 \
 4.611714285714286e-09 0.03333333333333333 \
 4.619642857142857e-09 0.03333333333333333 \
 4.620642857142858e-09 -0.1 \
 4.628571428571428e-09 -0.1 \
 4.629571428571429e-09 0.1 \
 4.6375e-09 0.1 \
 4.6385e-09 0.1 \
 4.646428571428571e-09 0.1 \
 4.647428571428572e-09 0.1 \
 4.655357142857143e-09 0.1 \
 4.656357142857143e-09 -0.03333333333333333 \
 4.664285714285714e-09 -0.03333333333333333 \
 4.665285714285714e-09 0.1 \
 4.673214285714286e-09 0.1 \
 4.674214285714286e-09 0.1 \
 4.682142857142857e-09 0.1 \
 4.683142857142857e-09 -0.03333333333333333 \
 4.691071428571429e-09 -0.03333333333333333 \
 4.692071428571429e-09 -0.1 \
 4.7e-09 -0.1 \
 4.701e-09 -0.03333333333333333 \
 4.708928571428572e-09 -0.03333333333333333 \
 4.709928571428572e-09 0.03333333333333333 \
 4.717857142857143e-09 0.03333333333333333 \
 4.718857142857143e-09 0.1 \
 4.726785714285715e-09 0.1 \
 4.727785714285715e-09 -0.1 \
 4.735714285714286e-09 -0.1 \
 4.736714285714286e-09 -0.1 \
 4.744642857142858e-09 -0.1 \
 4.745642857142858e-09 0.1 \
 4.753571428571429e-09 0.1 \
 4.754571428571429e-09 0.1 \
 4.7625e-09 0.1 \
 4.763500000000001e-09 0.03333333333333333 \
 4.771428571428571e-09 0.03333333333333333 \
 4.772428571428572e-09 0.03333333333333333 \
 4.780357142857143e-09 0.03333333333333333 \
 4.781357142857143e-09 -0.03333333333333333 \
 4.789285714285714e-09 -0.03333333333333333 \
 4.790285714285715e-09 0.1 \
 4.798214285714285e-09 0.1 \
 4.799214285714286e-09 0.1 \
 4.807142857142857e-09 0.1 \
 4.808142857142858e-09 -0.1 \
 4.816071428571428e-09 -0.1 \
 4.817071428571429e-09 -0.03333333333333333 \
 4.825e-09 -0.03333333333333333 \
 4.826e-09 0.1 \
 4.833928571428571e-09 0.1 \
 4.834928571428572e-09 -0.1 \
 4.842857142857143e-09 -0.1 \
 4.843857142857143e-09 0.03333333333333333 \
 4.851785714285714e-09 0.03333333333333333 \
 4.852785714285714e-09 0.1 \
 4.860714285714286e-09 0.1 \
 4.861714285714286e-09 -0.1 \
 4.869642857142857e-09 -0.1 \
 4.870642857142857e-09 0.03333333333333333 \
 4.878571428571429e-09 0.03333333333333333 \
 4.879571428571429e-09 -0.03333333333333333 \
 4.8875e-09 -0.03333333333333333 \
 4.8885e-09 0.03333333333333333 \
 4.896428571428572e-09 0.03333333333333333 \
 4.897428571428572e-09 -0.03333333333333333 \
 4.905357142857143e-09 -0.03333333333333333 \
 4.906357142857143e-09 -0.03333333333333333 \
 4.914285714285715e-09 -0.03333333333333333 \
 4.915285714285715e-09 0.1 \
 4.923214285714286e-09 0.1 \
 4.924214285714286e-09 -0.03333333333333333 \
 4.932142857142858e-09 -0.03333333333333333 \
 4.933142857142858e-09 -0.03333333333333333 \
 4.941071428571429e-09 -0.03333333333333333 \
 4.942071428571429e-09 0.1 \
 4.95e-09 0.1 \
 4.951e-09 0.1 \
 4.958928571428572e-09 0.1 \
 4.959928571428572e-09 -0.03333333333333333 \
 4.967857142857143e-09 -0.03333333333333333 \
 4.968857142857143e-09 0.03333333333333333 \
 4.976785714285714e-09 0.03333333333333333 \
 4.977785714285715e-09 0.03333333333333333 \
 4.985714285714285e-09 0.03333333333333333 \
 4.986714285714286e-09 -0.03333333333333333 \
 4.994642857142857e-09 -0.03333333333333333 \
 4.995642857142858e-09 -0.1 \
 5.003571428571428e-09 -0.1 \
 5.004571428571429e-09 0.03333333333333333 \
 5.0125e-09 0.03333333333333333 \
 5.013500000000001e-09 0.1 \
 5.021428571428571e-09 0.1 \
 5.022428571428572e-09 -0.1 \
 5.030357142857143e-09 -0.1 \
 5.031357142857143e-09 -0.03333333333333333 \
 5.039285714285714e-09 -0.03333333333333333 \
 5.040285714285714e-09 0.03333333333333333 \
 5.048214285714286e-09 0.03333333333333333 \
 5.049214285714286e-09 -0.1 \
 5.057142857142857e-09 -0.1 \
 5.058142857142857e-09 -0.1 \
 5.066071428571429e-09 -0.1 \
 5.067071428571429e-09 -0.03333333333333333 \
 5.075e-09 -0.03333333333333333 \
 5.076e-09 -0.1 \
 5.083928571428572e-09 -0.1 \
 5.084928571428572e-09 0.1 \
 5.092857142857143e-09 0.1 \
 5.093857142857143e-09 -0.03333333333333333 \
 5.101785714285715e-09 -0.03333333333333333 \
 5.102785714285715e-09 -0.03333333333333333 \
 5.110714285714286e-09 -0.03333333333333333 \
 5.111714285714286e-09 -0.1 \
 5.119642857142858e-09 -0.1 \
 5.120642857142858e-09 -0.03333333333333333 \
 5.128571428571429e-09 -0.03333333333333333 \
 5.129571428571429e-09 -0.03333333333333333 \
 5.1375e-09 -0.03333333333333333 \
 5.1385e-09 -0.03333333333333333 \
 5.146428571428572e-09 -0.03333333333333333 \
 5.147428571428572e-09 -0.03333333333333333 \
 5.155357142857143e-09 -0.03333333333333333 \
 5.156357142857143e-09 -0.03333333333333333 \
 5.164285714285714e-09 -0.03333333333333333 \
 5.165285714285715e-09 0.03333333333333333 \
 5.173214285714285e-09 0.03333333333333333 \
 5.174214285714286e-09 0.03333333333333333 \
 5.182142857142857e-09 0.03333333333333333 \
 5.183142857142858e-09 0.03333333333333333 \
 5.191071428571428e-09 0.03333333333333333 \
 5.192071428571429e-09 0.03333333333333333 \
 5.2e-09 0.03333333333333333 \
 5.201000000000001e-09 0.1 \
 5.208928571428571e-09 0.1 \
 5.209928571428572e-09 -0.1 \
 5.217857142857143e-09 -0.1 \
 5.218857142857143e-09 -0.03333333333333333 \
 5.226785714285714e-09 -0.03333333333333333 \
 5.227785714285714e-09 0.1 \
 5.235714285714286e-09 0.1 \
 5.236714285714286e-09 0.1 \
 5.244642857142857e-09 0.1 \
 5.245642857142857e-09 -0.03333333333333333 \
 5.253571428571429e-09 -0.03333333333333333 \
 5.254571428571429e-09 0.1 \
 5.2625e-09 0.1 \
 5.2635e-09 -0.03333333333333333 \
 5.271428571428572e-09 -0.03333333333333333 \
 5.272428571428572e-09 0.1 \
 5.280357142857143e-09 0.1 \
 5.281357142857143e-09 -0.1 \
 5.289285714285715e-09 -0.1 \
 5.290285714285715e-09 0.03333333333333333 \
 5.298214285714286e-09 0.03333333333333333 \
 5.299214285714286e-09 -0.1 \
 5.307142857142857e-09 -0.1 \
 5.308142857142857e-09 -0.03333333333333333 \
 5.316071428571429e-09 -0.03333333333333333 \
 5.317071428571429e-09 0.03333333333333333 \
 5.325e-09 0.03333333333333333 \
 5.326e-09 0.03333333333333333 \
 5.333928571428572e-09 0.03333333333333333 \
 5.334928571428572e-09 0.1 \
 5.342857142857143e-09 0.1 \
 5.343857142857143e-09 0.03333333333333333 \
 5.351785714285714e-09 0.03333333333333333 \
 5.352785714285715e-09 -0.03333333333333333 \
 5.360714285714286e-09 -0.03333333333333333 \
 5.361714285714286e-09 -0.1 \
 5.369642857142857e-09 -0.1 \
 5.370642857142858e-09 -0.1 \
 5.378571428571428e-09 -0.1 \
 5.379571428571429e-09 0.03333333333333333 \
 5.3875e-09 0.03333333333333333 \
 5.388500000000001e-09 0.1 \
 5.396428571428571e-09 0.1 \
 5.397428571428572e-09 -0.1 \
 5.405357142857143e-09 -0.1 \
 5.406357142857143e-09 -0.03333333333333333 \
 5.414285714285714e-09 -0.03333333333333333 \
 5.415285714285715e-09 -0.03333333333333333 \
 5.423214285714286e-09 -0.03333333333333333 \
 5.424214285714286e-09 0.1 \
 5.432142857142857e-09 0.1 \
 5.433142857142857e-09 -0.1 \
 5.441071428571429e-09 -0.1 \
 5.442071428571429e-09 0.1 \
 5.45e-09 0.1 \
 5.451e-09 -0.03333333333333333 \
 5.458928571428572e-09 -0.03333333333333333 \
 5.459928571428572e-09 0.1 \
 5.467857142857143e-09 0.1 \
 5.468857142857143e-09 0.1 \
 5.476785714285714e-09 0.1 \
 5.477785714285714e-09 0.03333333333333333 \
 5.485714285714286e-09 0.03333333333333333 \
 5.486714285714286e-09 -0.1 \
 5.494642857142857e-09 -0.1 \
 5.495642857142857e-09 0.1 \
 5.503571428571429e-09 0.1 \
 5.504571428571429e-09 0.1 \
 5.5125e-09 0.1 \
 5.5135e-09 0.03333333333333333 \
 5.521428571428572e-09 0.03333333333333333 \
 5.522428571428572e-09 -0.03333333333333333 \
 5.530357142857143e-09 -0.03333333333333333 \
 5.531357142857143e-09 -0.1 \
 5.539285714285714e-09 -0.1 \
 5.540285714285715e-09 -0.03333333333333333 \
 5.548214285714286e-09 -0.03333333333333333 \
 5.549214285714286e-09 -0.03333333333333333 \
 5.557142857142857e-09 -0.03333333333333333 \
 5.558142857142858e-09 0.1 \
 5.566071428571428e-09 0.1 \
 5.567071428571429e-09 -0.03333333333333333 \
 5.575e-09 -0.03333333333333333 \
 5.576000000000001e-09 0.1 \
 5.583928571428571e-09 0.1 \
 5.584928571428572e-09 0.1 \
 5.592857142857143e-09 0.1 \
 5.593857142857143e-09 -0.03333333333333333 \
 5.601785714285714e-09 -0.03333333333333333 \
 5.602785714285715e-09 0.1 \
 5.610714285714286e-09 0.1 \
 5.611714285714286e-09 0.1 \
 5.619642857142857e-09 0.1 \
 5.620642857142857e-09 0.1 \
 5.628571428571429e-09 0.1 \
 5.629571428571429e-09 -0.1 \
 5.6375e-09 -0.1 \
 5.6385e-09 0.03333333333333333 \
 5.646428571428572e-09 0.03333333333333333 \
 5.647428571428572e-09 -0.03333333333333333 \
 5.655357142857143e-09 -0.03333333333333333 \
 5.656357142857143e-09 0.1 \
 5.664285714285714e-09 0.1 \
 5.665285714285714e-09 -0.03333333333333333 \
 5.673214285714286e-09 -0.03333333333333333 \
 5.674214285714286e-09 -0.03333333333333333 \
 5.682142857142857e-09 -0.03333333333333333 \
 5.683142857142857e-09 -0.03333333333333333 \
 5.691071428571429e-09 -0.03333333333333333 \
 5.692071428571429e-09 -0.1 \
 5.7e-09 -0.1 \
 5.701e-09 -0.1 \
 5.708928571428572e-09 -0.1 \
 5.709928571428572e-09 0.1 \
 5.717857142857143e-09 0.1 \
 5.718857142857143e-09 0.1 \
 5.726785714285715e-09 0.1 \
 5.727785714285715e-09 0.1 \
 5.735714285714286e-09 0.1 \
 5.736714285714286e-09 -0.1 \
 5.744642857142857e-09 -0.1 \
 5.745642857142858e-09 0.1 \
 5.753571428571428e-09 0.1 \
 5.754571428571429e-09 -0.1 \
 5.7625e-09 -0.1 \
 5.763500000000001e-09 -0.03333333333333333 \
 5.771428571428571e-09 -0.03333333333333333 \
 5.772428571428572e-09 0.03333333333333333 \
 5.780357142857143e-09 0.03333333333333333 \
 5.781357142857144e-09 -0.03333333333333333 \
 5.789285714285714e-09 -0.03333333333333333 \
 5.790285714285715e-09 0.1 \
 5.798214285714286e-09 0.1 \
 5.799214285714286e-09 -0.1 \
 5.807142857142857e-09 -0.1 \
 5.808142857142857e-09 -0.03333333333333333 \
 5.816071428571429e-09 -0.03333333333333333 \
 5.817071428571429e-09 -0.03333333333333333 \
 5.825e-09 -0.03333333333333333 \
 5.826e-09 -0.03333333333333333 \
 5.833928571428571e-09 -0.03333333333333333 \
 5.834928571428571e-09 -0.1 \
 5.842857142857143e-09 -0.1 \
 5.843857142857143e-09 -0.1 \
 5.851785714285714e-09 -0.1 \
 5.852785714285714e-09 0.03333333333333333 \
 5.860714285714286e-09 0.03333333333333333 \
 5.861714285714286e-09 -0.03333333333333333 \
 5.869642857142857e-09 -0.03333333333333333 \
 5.870642857142857e-09 -0.1 \
 5.878571428571429e-09 -0.1 \
 5.879571428571429e-09 0.1 \
 5.8875e-09 0.1 \
 5.8885e-09 -0.03333333333333333 \
 5.896428571428572e-09 -0.03333333333333333 \
 5.897428571428572e-09 -0.03333333333333333 \
 5.905357142857143e-09 -0.03333333333333333 \
 5.906357142857143e-09 0.1 \
 5.914285714285715e-09 0.1 \
 5.915285714285715e-09 -0.1 \
 5.923214285714286e-09 -0.1 \
 5.924214285714286e-09 0.1 \
 5.932142857142857e-09 0.1 \
 5.933142857142858e-09 -0.03333333333333333 \
 5.941071428571428e-09 -0.03333333333333333 \
 5.942071428571429e-09 -0.03333333333333333 \
 5.95e-09 -0.03333333333333333 \
 5.951000000000001e-09 0.1 \
 5.958928571428571e-09 0.1 \
 5.959928571428572e-09 -0.03333333333333333 \
 5.967857142857143e-09 -0.03333333333333333 \
 5.968857142857144e-09 -0.1 \
 5.976785714285714e-09 -0.1 \
 5.977785714285715e-09 -0.03333333333333333 \
 5.985714285714286e-09 -0.03333333333333333 \
 5.986714285714286e-09 0.03333333333333333 \
 5.994642857142857e-09 0.03333333333333333 \
 5.995642857142857e-09 0.1 \
 6.003571428571428e-09 0.1 \
 6.004571428571429e-09 -0.1 \
 6.0125e-09 -0.1 \
 6.0135e-09 0.1 \
 6.021428571428571e-09 0.1 \
 6.022428571428571e-09 0.03333333333333333 \
 6.030357142857143e-09 0.03333333333333333 \
 6.031357142857143e-09 -0.03333333333333333 \
 6.039285714285714e-09 -0.03333333333333333 \
 6.040285714285714e-09 -0.03333333333333333 \
 6.048214285714286e-09 -0.03333333333333333 \
 6.049214285714286e-09 0.03333333333333333 \
 6.057142857142857e-09 0.03333333333333333 \
 6.058142857142857e-09 0.1 \
 6.066071428571429e-09 0.1 \
 6.067071428571429e-09 0.03333333333333333 \
 6.075e-09 0.03333333333333333 \
 6.076e-09 0.03333333333333333 \
 6.083928571428572e-09 0.03333333333333333 \
 6.084928571428572e-09 -0.03333333333333333 \
 6.092857142857143e-09 -0.03333333333333333 \
 6.093857142857143e-09 0.03333333333333333 \
 6.101785714285715e-09 0.03333333333333333 \
 6.102785714285715e-09 0.1 \
 6.110714285714286e-09 0.1 \
 6.111714285714286e-09 -0.1 \
 6.119642857142857e-09 -0.1 \
 6.120642857142858e-09 -0.03333333333333333 \
 6.128571428571429e-09 -0.03333333333333333 \
 6.129571428571429e-09 -0.1 \
 6.1375e-09 -0.1 \
 6.138500000000001e-09 -0.1 \
 6.146428571428571e-09 -0.1 \
 6.147428571428572e-09 0.03333333333333333 \
 6.155357142857143e-09 0.03333333333333333 \
 6.156357142857144e-09 0.03333333333333333 \
 6.164285714285714e-09 0.03333333333333333 \
 6.165285714285715e-09 -0.03333333333333333 \
 6.173214285714286e-09 -0.03333333333333333 \
 6.174214285714286e-09 0.03333333333333333 \
 6.182142857142857e-09 0.03333333333333333 \
 6.183142857142858e-09 -0.03333333333333333 \
 6.191071428571428e-09 -0.03333333333333333 \
 6.192071428571429e-09 0.1 \
 6.2e-09 0.1 \
 6.201e-09 -0.03333333333333333 \
 6.208928571428571e-09 -0.03333333333333333 \
 6.209928571428571e-09 0.03333333333333333 \
 6.217857142857143e-09 0.03333333333333333 \
 6.218857142857143e-09 0.03333333333333333 \
 6.226785714285714e-09 0.03333333333333333 \
 6.227785714285714e-09 -0.03333333333333333 \
 6.235714285714286e-09 -0.03333333333333333 \
 6.236714285714286e-09 0.03333333333333333 \
 6.244642857142857e-09 0.03333333333333333 \
 6.245642857142857e-09 -0.1 \
 6.253571428571429e-09 -0.1 \
 6.254571428571429e-09 -0.03333333333333333 \
 6.2625e-09 -0.03333333333333333 \
 6.2635e-09 0.1 \
 6.271428571428572e-09 0.1 \
 6.272428571428572e-09 0.03333333333333333 \
 6.280357142857143e-09 0.03333333333333333 \
 6.281357142857143e-09 -0.03333333333333333 \
 6.289285714285715e-09 -0.03333333333333333 \
 6.290285714285715e-09 -0.03333333333333333 \
 6.298214285714286e-09 -0.03333333333333333 \
 6.299214285714286e-09 -0.03333333333333333 \
 6.307142857142857e-09 -0.03333333333333333 \
 6.308142857142858e-09 -0.1 \
 6.316071428571429e-09 -0.1 \
 6.317071428571429e-09 0.03333333333333333 \
 6.325e-09 0.03333333333333333 \
 6.326000000000001e-09 -0.1 \
 6.333928571428571e-09 -0.1 \
 6.334928571428572e-09 -0.1 \
 6.342857142857143e-09 -0.1 \
 6.343857142857144e-09 0.03333333333333333 \
 6.351785714285714e-09 0.03333333333333333 \
 6.352785714285715e-09 -0.1 \
 6.360714285714285e-09 -0.1 \
 6.361714285714286e-09 -0.1 \
 6.369642857142857e-09 -0.1 \
 6.370642857142858e-09 0.1 \
 6.378571428571428e-09 0.1 \
 6.379571428571429e-09 -0.1 \
 6.3875e-09 -0.1 \
 6.3885e-09 0.03333333333333333 \
 6.396428571428571e-09 0.03333333333333333 \
 6.397428571428571e-09 0.1 \
 6.405357142857143e-09 0.1 \
 6.406357142857143e-09 0.03333333333333333 \
 6.414285714285714e-09 0.03333333333333333 \
 6.415285714285714e-09 -0.1 \
 6.423214285714286e-09 -0.1 \
 6.424214285714286e-09 0.03333333333333333 \
 6.432142857142857e-09 0.03333333333333333 \
 6.433142857142857e-09 -0.1 \
 6.441071428571429e-09 -0.1 \
 6.442071428571429e-09 -0.03333333333333333 \
 6.45e-09 -0.03333333333333333 \
 6.451e-09 0.03333333333333333 \
 6.458928571428572e-09 0.03333333333333333 \
 6.459928571428572e-09 -0.03333333333333333 \
 6.467857142857143e-09 -0.03333333333333333 \
 6.468857142857143e-09 0.1 \
 6.476785714285715e-09 0.1 \
 6.477785714285715e-09 -0.03333333333333333 \
 6.485714285714286e-09 -0.03333333333333333 \
 6.486714285714286e-09 0.03333333333333333 \
 6.494642857142858e-09 0.03333333333333333 \
 6.495642857142858e-09 -0.1 \
 6.503571428571429e-09 -0.1 \
 6.504571428571429e-09 0.1 \
 6.5125e-09 0.1 \
 6.513500000000001e-09 -0.1 \
 6.521428571428571e-09 -0.1 \
 6.522428571428572e-09 -0.1 \
 6.530357142857142e-09 -0.1 \
 6.531357142857143e-09 0.03333333333333333 \
 6.539285714285714e-09 0.03333333333333333 \
 6.540285714285715e-09 0.1 \
 6.548214285714285e-09 0.1 \
 6.549214285714286e-09 0.03333333333333333 \
 6.557142857142857e-09 0.03333333333333333 \
 6.558142857142858e-09 -0.1 \
 6.566071428571428e-09 -0.1 \
 6.567071428571429e-09 -0.03333333333333333 \
 6.575e-09 -0.03333333333333333 \
 6.576e-09 -0.1 \
 6.583928571428571e-09 -0.1 \
 6.584928571428571e-09 -0.1 \
 6.592857142857143e-09 -0.1 \
 6.593857142857143e-09 -0.1 \
 6.601785714285714e-09 -0.1 \
 6.602785714285714e-09 -0.1 \
 6.610714285714286e-09 -0.1 \
 6.611714285714286e-09 0.03333333333333333 \
 6.619642857142857e-09 0.03333333333333333 \
 6.620642857142857e-09 -0.03333333333333333 \
 6.628571428571429e-09 -0.03333333333333333 \
 6.629571428571429e-09 -0.1 \
 6.6375e-09 -0.1 \
 6.6385e-09 -0.1 \
 6.646428571428572e-09 -0.1 \
 6.647428571428572e-09 0.03333333333333333 \
 6.655357142857143e-09 0.03333333333333333 \
 6.656357142857143e-09 0.03333333333333333 \
 6.664285714285715e-09 0.03333333333333333 \
 6.665285714285715e-09 0.1 \
 6.673214285714286e-09 0.1 \
 6.674214285714286e-09 -0.1 \
 6.682142857142858e-09 -0.1 \
 6.683142857142858e-09 0.03333333333333333 \
 6.691071428571429e-09 0.03333333333333333 \
 6.692071428571429e-09 -0.03333333333333333 \
 6.7e-09 -0.03333333333333333 \
 6.701000000000001e-09 -0.1 \
 6.708928571428571e-09 -0.1 \
 6.709928571428572e-09 -0.03333333333333333 \
 6.717857142857143e-09 -0.03333333333333333 \
 6.718857142857143e-09 0.03333333333333333 \
 6.726785714285714e-09 0.03333333333333333 \
 6.727785714285715e-09 0.03333333333333333 \
 6.735714285714285e-09 0.03333333333333333 \
 6.736714285714286e-09 -0.03333333333333333 \
 6.744642857142857e-09 -0.03333333333333333 \
 6.745642857142858e-09 -0.03333333333333333 \
 6.753571428571428e-09 -0.03333333333333333 \
 6.754571428571429e-09 0.03333333333333333 \
 6.7625e-09 0.03333333333333333 \
 6.7635e-09 0.03333333333333333 \
 6.771428571428571e-09 0.03333333333333333 \
 6.772428571428572e-09 -0.03333333333333333 \
 6.780357142857143e-09 -0.03333333333333333 \
 6.781357142857143e-09 -0.1 \
 6.789285714285714e-09 -0.1 \
 6.790285714285714e-09 0.1 \
 6.798214285714286e-09 0.1 \
 6.799214285714286e-09 0.03333333333333333 \
 6.807142857142857e-09 0.03333333333333333 \
 6.808142857142857e-09 0.1 \
 6.816071428571429e-09 0.1 \
 6.817071428571429e-09 0.1 \
 6.825e-09 0.1 \
 6.826e-09 -0.1 \
 6.833928571428572e-09 -0.1 \
 6.834928571428572e-09 -0.1 \
 6.842857142857143e-09 -0.1 \
 6.843857142857143e-09 0.1 \
 6.851785714285715e-09 0.1 \
 6.852785714285715e-09 -0.1 \
 6.860714285714286e-09 -0.1 \
 6.861714285714286e-09 0.1 \
 6.869642857142858e-09 0.1 \
 6.870642857142858e-09 0.03333333333333333 \
 6.878571428571429e-09 0.03333333333333333 \
 6.879571428571429e-09 0.1 \
 6.8875e-09 0.1 \
 6.8885e-09 0.1 \
 6.896428571428571e-09 0.1 \
 6.897428571428572e-09 0.1 \
 6.905357142857143e-09 0.1 \
 6.906357142857143e-09 -0.1 \
 6.914285714285714e-09 -0.1 \
 6.915285714285715e-09 0.03333333333333333 \
 6.923214285714285e-09 0.03333333333333333 \
 6.924214285714286e-09 -0.03333333333333333 \
 6.932142857142857e-09 -0.03333333333333333 \
 6.933142857142858e-09 0.03333333333333333 \
 6.941071428571428e-09 0.03333333333333333 \
 6.942071428571429e-09 0.1 \
 6.95e-09 0.1 \
 6.951000000000001e-09 0.03333333333333333 \
 6.958928571428571e-09 0.03333333333333333 \
 6.959928571428572e-09 -0.03333333333333333 \
 6.967857142857143e-09 -0.03333333333333333 \
 6.968857142857143e-09 0.1 \
 6.976785714285714e-09 0.1 \
 6.977785714285714e-09 0.03333333333333333 \
 6.985714285714286e-09 0.03333333333333333 \
 6.986714285714286e-09 -0.03333333333333333 \
 6.994642857142857e-09 -0.03333333333333333 \
 6.995642857142857e-09 -0.1 \
 7.003571428571429e-09 -0.1 \
 7.004571428571429e-09 -0.1 \
 7.0125e-09 -0.1 \
 7.0135e-09 0.1 \
 7.021428571428572e-09 0.1 \
 7.022428571428572e-09 0.1 \
 7.030357142857143e-09 0.1 \
 7.031357142857143e-09 0.03333333333333333 \
 7.039285714285715e-09 0.03333333333333333 \
 7.040285714285715e-09 -0.1 \
 7.048214285714286e-09 -0.1 \
 7.049214285714286e-09 0.03333333333333333 \
 7.057142857142857e-09 0.03333333333333333 \
 7.058142857142857e-09 0.03333333333333333 \
 7.066071428571429e-09 0.03333333333333333 \
 7.067071428571429e-09 0.1 \
 7.075e-09 0.1 \
 7.076e-09 0.03333333333333333 \
 7.083928571428572e-09 0.03333333333333333 \
 7.084928571428572e-09 0.1 \
 7.092857142857143e-09 0.1 \
 7.093857142857143e-09 -0.03333333333333333 \
 7.101785714285714e-09 -0.03333333333333333 \
 7.102785714285715e-09 -0.1 \
 7.110714285714285e-09 -0.1 \
 7.111714285714286e-09 -0.1 \
 7.119642857142857e-09 -0.1 \
 7.120642857142858e-09 -0.03333333333333333 \
 7.128571428571428e-09 -0.03333333333333333 \
 7.129571428571429e-09 -0.1 \
 7.1375e-09 -0.1 \
 7.138500000000001e-09 -0.03333333333333333 \
 7.146428571428571e-09 -0.03333333333333333 \
 7.147428571428572e-09 -0.1 \
 7.155357142857143e-09 -0.1 \
 7.156357142857143e-09 -0.03333333333333333 \
 7.164285714285714e-09 -0.03333333333333333 \
 7.165285714285714e-09 -0.03333333333333333 \
 7.173214285714286e-09 -0.03333333333333333 \
 7.174214285714286e-09 -0.03333333333333333 \
 7.182142857142857e-09 -0.03333333333333333 \
 7.183142857142857e-09 -0.1 \
 7.191071428571429e-09 -0.1 \
 7.192071428571429e-09 -0.03333333333333333 \
 7.2e-09 -0.03333333333333333 \
 7.201e-09 -0.03333333333333333 \
 7.208928571428572e-09 -0.03333333333333333 \
 7.209928571428572e-09 0.03333333333333333 \
 7.217857142857143e-09 0.03333333333333333 \
 7.218857142857143e-09 -0.1 \
 7.226785714285715e-09 -0.1 \
 7.227785714285715e-09 -0.03333333333333333 \
 7.235714285714286e-09 -0.03333333333333333 \
 7.236714285714286e-09 -0.1 \
 7.244642857142857e-09 -0.1 \
 7.245642857142857e-09 -0.1 \
 7.253571428571429e-09 -0.1 \
 7.254571428571429e-09 -0.1 \
 7.2625e-09 -0.1 \
 7.2635e-09 0.1 \
 7.271428571428572e-09 0.1 \
 7.272428571428572e-09 0.1 \
 7.280357142857143e-09 0.1 \
 7.281357142857143e-09 0.03333333333333333 \
 7.289285714285714e-09 0.03333333333333333 \
 7.290285714285715e-09 0.1 \
 7.298214285714285e-09 0.1 \
 7.299214285714286e-09 0.1 \
 7.307142857142857e-09 0.1 \
 7.308142857142858e-09 0.1 \
 7.316071428571428e-09 0.1 \
 7.317071428571429e-09 -0.1 \
 7.325e-09 -0.1 \
 7.326000000000001e-09 0.03333333333333333 \
 7.333928571428571e-09 0.03333333333333333 \
 7.334928571428572e-09 -0.03333333333333333 \
 7.342857142857143e-09 -0.03333333333333333 \
 7.343857142857143e-09 -0.03333333333333333 \
 7.351785714285714e-09 -0.03333333333333333 \
 7.352785714285714e-09 -0.1 \
 7.360714285714286e-09 -0.1 \
 7.361714285714286e-09 0.1 \
 7.369642857142857e-09 0.1 \
 7.370642857142857e-09 0.1 \
 7.378571428571429e-09 0.1 \
 7.379571428571429e-09 -0.03333333333333333 \
 7.3875e-09 -0.03333333333333333 \
 7.3885e-09 0.03333333333333333 \
 7.396428571428572e-09 0.03333333333333333 \
 7.397428571428572e-09 0.1 \
 7.405357142857143e-09 0.1 \
 7.406357142857143e-09 0.1 \
 7.414285714285714e-09 0.1 \
 7.415285714285714e-09 0.1 \
 7.423214285714286e-09 0.1 \
 7.424214285714286e-09 0.03333333333333333 \
 7.432142857142857e-09 0.03333333333333333 \
 7.433142857142857e-09 -0.1 \
 7.441071428571429e-09 -0.1 \
 7.442071428571429e-09 0.03333333333333333 \
 7.45e-09 0.03333333333333333 \
 7.451e-09 0.1 \
 7.458928571428571e-09 0.1 \
 7.45992857142857e-09 -0.1 \
 7.467857142857143e-09 -0.1 \
 7.468857142857142e-09 0.1 \
 7.476785714285714e-09 0.1 \
 7.477785714285714e-09 -0.03333333333333333 \
 7.485714285714285e-09 -0.03333333333333333 \
 7.486714285714284e-09 -0.03333333333333333 \
 7.494642857142857e-09 -0.03333333333333333 \
 7.495642857142856e-09 -0.1 \
 7.503571428571428e-09 -0.1 \
 7.504571428571428e-09 0.1 \
 7.5125e-09 0.1 \
 7.5135e-09 0.1 \
 7.52142857142857e-09 0.1 \
 7.52242857142857e-09 -0.1 \
 7.530357142857142e-09 -0.1 \
 7.531357142857142e-09 -0.1 \
 7.539285714285714e-09 -0.1 \
 7.540285714285714e-09 -0.1 \
 7.548214285714286e-09 -0.1 \
 7.549214285714286e-09 0.1 \
 7.557142857142856e-09 0.1 \
 7.558142857142856e-09 -0.03333333333333333 \
 7.566071428571428e-09 -0.03333333333333333 \
 7.567071428571428e-09 -0.1 \
 7.575e-09 -0.1 \
 7.575999999999999e-09 0.03333333333333333 \
 7.583928571428572e-09 0.03333333333333333 \
 7.584928571428571e-09 -0.03333333333333333 \
 7.592857142857142e-09 -0.03333333333333333 \
 7.593857142857142e-09 -0.03333333333333333 \
 7.601785714285714e-09 -0.03333333333333333 \
 7.602785714285713e-09 -0.1 \
 7.610714285714286e-09 -0.1 \
 7.611714285714285e-09 0.03333333333333333 \
 7.619642857142856e-09 0.03333333333333333 \
 7.620642857142855e-09 -0.03333333333333333 \
 7.628571428571428e-09 -0.03333333333333333 \
 7.629571428571427e-09 0.1 \
 7.6375e-09 0.1 \
 7.638499999999999e-09 0.1 \
 7.646428571428572e-09 0.1 \
 7.647428571428571e-09 -0.1 \
 7.655357142857143e-09 -0.1 \
 7.656357142857143e-09 0.03333333333333333 \
 7.664285714285714e-09 0.03333333333333333 \
 7.665285714285713e-09 -0.03333333333333333 \
 7.673214285714286e-09 -0.03333333333333333 \
 7.674214285714285e-09 0.03333333333333333 \
 7.682142857142857e-09 0.03333333333333333 \
 7.683142857142857e-09 -0.03333333333333333 \
 7.691071428571429e-09 -0.03333333333333333 \
 7.692071428571429e-09 -0.03333333333333333 \
 7.699999999999999e-09 -0.03333333333333333 \
 7.700999999999999e-09 0.1 \
 7.708928571428571e-09 0.1 \
 7.709928571428571e-09 -0.1 \
 7.717857142857143e-09 -0.1 \
 7.718857142857143e-09 0.03333333333333333 \
 7.726785714285715e-09 0.03333333333333333 \
 7.727785714285715e-09 -0.1 \
 7.735714285714285e-09 -0.1 \
 7.736714285714285e-09 -0.03333333333333333 \
 7.744642857142857e-09 -0.03333333333333333 \
 7.745642857142857e-09 0.1 \
 7.753571428571429e-09 0.1 \
 7.754571428571428e-09 -0.03333333333333333 \
 7.762499999999999e-09 -0.03333333333333333 \
 7.763499999999999e-09 0.1 \
 7.771428571428571e-09 0.1 \
 7.772428571428571e-09 0.1 \
 7.780357142857143e-09 0.1 \
 7.781357142857142e-09 -0.1 \
 7.789285714285715e-09 -0.1 \
 7.790285714285714e-09 0.1 \
 7.798214285714285e-09 0.1 \
 7.799214285714284e-09 0.03333333333333333 \
 7.807142857142857e-09 0.03333333333333333 \
 7.808142857142856e-09 0.03333333333333333 \
 7.816071428571429e-09 0.03333333333333333 \
 7.817071428571428e-09 -0.1 \
 7.825000000000001e-09 -0.1 \
 7.826e-09 -0.1 \
 7.833928571428571e-09 -0.1 \
 7.83492857142857e-09 -0.03333333333333333 \
 7.842857142857143e-09 -0.03333333333333333 \
 7.843857142857142e-09 -0.03333333333333333 \
 7.851785714285715e-09 -0.03333333333333333 \
 7.852785714285714e-09 -0.03333333333333333 \
 7.860714285714286e-09 -0.03333333333333333 \
 7.861714285714286e-09 0.1 \
 7.869642857142857e-09 0.1 \
 7.870642857142856e-09 -0.1 \
 7.878571428571428e-09 -0.1 \
 7.879571428571428e-09 0.1 \
 7.8875e-09 0.1 \
 7.8885e-09 0.03333333333333333 \
 7.896428571428572e-09 0.03333333333333333 \
 7.897428571428572e-09 -0.1 \
 7.905357142857142e-09 -0.1 \
 7.906357142857142e-09 0.03333333333333333 \
 7.914285714285714e-09 0.03333333333333333 \
 7.915285714285714e-09 0.03333333333333333 \
 7.923214285714286e-09 0.03333333333333333 \
 7.924214285714286e-09 0.1 \
 7.932142857142858e-09 0.1 \
 7.933142857142857e-09 -0.03333333333333333 \
 7.941071428571428e-09 -0.03333333333333333 \
 7.942071428571428e-09 -0.1 \
 7.95e-09 -0.1 \
 7.951e-09 -0.03333333333333333 \
 7.958928571428572e-09 -0.03333333333333333 \
 7.959928571428571e-09 -0.1 \
 7.967857142857142e-09 -0.1 \
 7.968857142857142e-09 -0.1 \
 7.976785714285714e-09 -0.1 \
 7.977785714285713e-09 -0.03333333333333333 \
 7.985714285714286e-09 -0.03333333333333333 \
 7.986714285714285e-09 -0.1 \
 7.994642857142858e-09 -0.1 \
 7.995642857142857e-09 -0.1 \
 8.003571428571428e-09 -0.1 \
 8.004571428571427e-09 0.1 \
 8.0125e-09 0.1 \
 8.013499999999999e-09 0.03333333333333333 \
 8.021428571428572e-09 0.03333333333333333 \
 8.022428571428571e-09 0.1 \
 8.030357142857144e-09 0.1 \
 8.031357142857143e-09 -0.1 \
 8.039285714285714e-09 -0.1 \
 8.040285714285713e-09 0.03333333333333333 \
 8.048214285714286e-09 0.03333333333333333 \
 8.049214285714285e-09 0.03333333333333333 \
 8.057142857142857e-09 0.03333333333333333 \
 8.058142857142857e-09 -0.1 \
 8.066071428571429e-09 -0.1 \
 8.067071428571429e-09 -0.03333333333333333 \
 8.075e-09 -0.03333333333333333 \
 8.075999999999999e-09 0.03333333333333333 \
 8.083928571428571e-09 0.03333333333333333 \
 8.084928571428571e-09 0.03333333333333333 \
 8.092857142857143e-09 0.03333333333333333 \
 8.093857142857143e-09 -0.1 \
 8.101785714285715e-09 -0.1 \
 8.102785714285715e-09 -0.1 \
 8.110714285714285e-09 -0.1 \
 8.111714285714285e-09 -0.03333333333333333 \
 8.119642857142857e-09 -0.03333333333333333 \
 8.120642857142857e-09 -0.1 \
 8.128571428571429e-09 -0.1 \
 8.129571428571429e-09 0.1 \
 8.137499999999999e-09 0.1 \
 8.138499999999999e-09 -0.03333333333333333 \
 8.146428571428571e-09 -0.03333333333333333 \
 8.147428571428571e-09 -0.1 \
 8.155357142857143e-09 -0.1 \
 8.156357142857142e-09 -0.1 \
 8.164285714285715e-09 -0.1 \
 8.165285714285714e-09 -0.03333333333333333 \
 8.173214285714285e-09 -0.03333333333333333 \
 8.174214285714285e-09 -0.03333333333333333 \
 8.182142857142857e-09 -0.03333333333333333 \
 8.183142857142856e-09 -0.1 \
 8.191071428571429e-09 -0.1 \
 8.192071428571428e-09 0.1 \
 8.200000000000001e-09 0.1 \
 8.201e-09 -0.1 \
 8.208928571428571e-09 -0.1 \
 8.20992857142857e-09 -0.1 \
 8.217857142857143e-09 -0.1 \
 8.218857142857142e-09 -0.03333333333333333 \
 8.226785714285715e-09 -0.03333333333333333 \
 8.227785714285714e-09 0.03333333333333333 \
 8.235714285714286e-09 0.03333333333333333 \
 8.236714285714286e-09 0.03333333333333333 \
 8.244642857142857e-09 0.03333333333333333 \
 8.245642857142856e-09 0.03333333333333333 \
 8.253571428571429e-09 0.03333333333333333 \
 8.254571428571428e-09 0.1 \
 8.2625e-09 0.1 \
 8.2635e-09 0.1 \
 8.271428571428572e-09 0.1 \
 8.272428571428572e-09 -0.03333333333333333 \
 8.280357142857142e-09 -0.03333333333333333 \
 8.281357142857142e-09 0.1 \
 8.289285714285714e-09 0.1 \
 8.290285714285714e-09 0.1 \
 8.298214285714286e-09 0.1 \
 8.299214285714286e-09 -0.03333333333333333 \
 8.307142857142856e-09 -0.03333333333333333 \
 8.308142857142856e-09 -0.03333333333333333 \
 8.316071428571428e-09 -0.03333333333333333 \
 8.317071428571428e-09 -0.03333333333333333 \
 8.325e-09 -0.03333333333333333 \
 8.326e-09 0.03333333333333333 \
 8.333928571428572e-09 0.03333333333333333 \
 8.334928571428571e-09 0.1 \
 8.342857142857142e-09 0.1 \
 8.343857142857142e-09 0.03333333333333333 \
 8.351785714285714e-09 0.03333333333333333 \
 8.352785714285714e-09 -0.03333333333333333 \
 8.360714285714286e-09 -0.03333333333333333 \
 8.361714285714285e-09 -0.1 \
 8.369642857142858e-09 -0.1 \
 8.370642857142857e-09 -0.1 \
 8.378571428571428e-09 -0.1 \
 8.379571428571427e-09 -0.03333333333333333 \
 8.3875e-09 -0.03333333333333333 \
 8.388499999999999e-09 -0.1 \
 8.396428571428572e-09 -0.1 \
 8.397428571428571e-09 0.03333333333333333 \
 8.405357142857144e-09 0.03333333333333333 \
 8.406357142857143e-09 -0.1 \
 8.414285714285714e-09 -0.1 \
 8.415285714285713e-09 0.03333333333333333 \
 8.423214285714286e-09 0.03333333333333333 \
 8.424214285714285e-09 0.1 \
 8.432142857142857e-09 0.1 \
 8.433142857142857e-09 0.03333333333333333 \
 8.441071428571429e-09 0.03333333333333333 \
 8.442071428571429e-09 0.03333333333333333 \
 8.45e-09 0.03333333333333333 \
 8.450999999999999e-09 0.03333333333333333 \
 8.458928571428571e-09 0.03333333333333333 \
 8.459928571428571e-09 0.1 \
 8.467857142857143e-09 0.1 \
 8.468857142857143e-09 -0.03333333333333333 \
 8.476785714285713e-09 -0.03333333333333333 \
 8.477785714285713e-09 -0.1 \
 8.485714285714285e-09 -0.1 \
 8.486714285714285e-09 0.03333333333333333 \
 8.494642857142857e-09 0.03333333333333333 \
 8.495642857142857e-09 -0.03333333333333333 \
 8.503571428571429e-09 -0.03333333333333333 \
 8.504571428571429e-09 -0.1 \
 8.512499999999999e-09 -0.1 \
 8.513499999999999e-09 0.1 \
 8.521428571428571e-09 0.1 \
 8.522428571428571e-09 0.03333333333333333 \
 8.530357142857143e-09 0.03333333333333333 \
 8.531357142857143e-09 0.03333333333333333 \
 8.539285714285715e-09 0.03333333333333333 \
 8.540285714285714e-09 0.03333333333333333 \
 8.548214285714285e-09 0.03333333333333333 \
 8.549214285714285e-09 0.1 \
 8.557142857142857e-09 0.1 \
 8.558142857142856e-09 0.03333333333333333 \
 8.566071428571429e-09 0.03333333333333333 \
 8.567071428571428e-09 -0.1 \
 8.575000000000001e-09 -0.1 \
 8.576e-09 -0.1 \
 8.583928571428571e-09 -0.1 \
 8.58492857142857e-09 0.1 \
 8.592857142857143e-09 0.1 \
 8.593857142857142e-09 -0.03333333333333333 \
 8.601785714285715e-09 -0.03333333333333333 \
 8.602785714285714e-09 0.1 \
 8.610714285714286e-09 0.1 \
 8.611714285714286e-09 -0.03333333333333333 \
 8.619642857142857e-09 -0.03333333333333333 \
 8.620642857142856e-09 -0.1 \
 8.628571428571429e-09 -0.1 \
 8.629571428571428e-09 0.1 \
 8.6375e-09 0.1 \
 8.6385e-09 -0.03333333333333333 \
 8.646428571428571e-09 -0.03333333333333333 \
 8.64742857142857e-09 0.1 \
 8.655357142857142e-09 0.1 \
 8.656357142857142e-09 0.03333333333333333 \
 8.664285714285714e-09 0.03333333333333333 \
 8.665285714285714e-09 -0.1 \
 8.673214285714286e-09 -0.1 \
 8.674214285714286e-09 0.1 \
 8.682142857142856e-09 0.1 \
 8.683142857142856e-09 0.1 \
 8.691071428571428e-09 0.1 \
 8.692071428571428e-09 -0.1 \
 8.7e-09 -0.1 \
 8.701e-09 0.1 \
 8.708928571428572e-09 0.1 \
 8.709928571428571e-09 0.03333333333333333 \
 8.717857142857142e-09 0.03333333333333333 \
 8.718857142857142e-09 0.03333333333333333 \
 8.726785714285714e-09 0.03333333333333333 \
 8.727785714285714e-09 0.03333333333333333 \
 8.735714285714286e-09 0.03333333333333333 \
 8.736714285714285e-09 -0.03333333333333333 \
 8.744642857142858e-09 -0.03333333333333333 \
 8.745642857142857e-09 0.03333333333333333 \
 8.753571428571428e-09 0.03333333333333333 \
 8.754571428571427e-09 -0.03333333333333333 \
 8.7625e-09 -0.03333333333333333 \
 8.763499999999999e-09 0.03333333333333333 \
 8.771428571428572e-09 0.03333333333333333 \
 8.772428571428571e-09 0.03333333333333333 \
 8.780357142857144e-09 0.03333333333333333 \
 8.781357142857143e-09 0.03333333333333333 \
 8.789285714285714e-09 0.03333333333333333 \
 8.790285714285713e-09 0.1 \
 8.798214285714286e-09 0.1 \
 8.799214285714285e-09 -0.03333333333333333 \
 8.807142857142858e-09 -0.03333333333333333 \
 8.808142857142857e-09 0.1 \
 8.816071428571428e-09 0.1 \
 8.817071428571427e-09 -0.03333333333333333 \
 8.825e-09 -0.03333333333333333 \
 8.825999999999999e-09 0.03333333333333333 \
 8.833928571428571e-09 0.03333333333333333 \
 8.834928571428571e-09 0.1 \
 8.842857142857143e-09 0.1 \
 8.843857142857143e-09 -0.1 \
 8.851785714285714e-09 -0.1 \
 8.852785714285713e-09 0.1 \
 8.860714285714285e-09 0.1 \
 8.861714285714285e-09 -0.1 \
 8.869642857142857e-09 -0.1 \
 8.870642857142857e-09 -0.1 \
 8.878571428571429e-09 -0.1 \
 8.879571428571429e-09 -0.1 \
 8.887499999999999e-09 -0.1 \
 8.888499999999999e-09 -0.1 \
 8.896428571428571e-09 -0.1 \
 8.897428571428571e-09 0.03333333333333333 \
 8.905357142857143e-09 0.03333333333333333 \
 8.906357142857143e-09 -0.03333333333333333 \
 8.914285714285715e-09 -0.03333333333333333 \
 8.915285714285714e-09 0.03333333333333333 \
 8.923214285714285e-09 0.03333333333333333 \
 8.924214285714285e-09 -0.03333333333333333 \
 8.932142857142857e-09 -0.03333333333333333 \
 8.933142857142856e-09 -0.03333333333333333 \
 8.941071428571429e-09 -0.03333333333333333 \
 8.942071428571428e-09 -0.1 \
 8.950000000000001e-09 -0.1 \
 8.951e-09 0.1 \
 8.958928571428571e-09 0.1 \
 8.95992857142857e-09 0.1 \
 8.967857142857143e-09 0.1 \
 8.968857142857142e-09 0.03333333333333333 \
 8.976785714285715e-09 0.03333333333333333 \
 8.977785714285714e-09 -0.03333333333333333 \
 8.985714285714287e-09 -0.03333333333333333 \
 8.986714285714286e-09 -0.03333333333333333 \
 8.994642857142857e-09 -0.03333333333333333 \
 8.995642857142856e-09 -0.1 \
 9.003571428571429e-09 -0.1 \
 9.004571428571428e-09 0.03333333333333333 \
 9.0125e-09 0.03333333333333333 \
 9.0135e-09 0.03333333333333333 \
 9.021428571428571e-09 0.03333333333333333 \
 9.02242857142857e-09 0.03333333333333333 \
 9.030357142857143e-09 0.03333333333333333 \
 9.031357142857142e-09 -0.1 \
 9.039285714285714e-09 -0.1 \
 9.040285714285714e-09 -0.03333333333333333 \
 9.048214285714286e-09 -0.03333333333333333 \
 9.049214285714286e-09 0.03333333333333333 \
 9.057142857142856e-09 0.03333333333333333 \
 9.058142857142856e-09 -0.1 \
 9.066071428571428e-09 -0.1 \
 9.067071428571428e-09 0.03333333333333333 \
 9.075e-09 0.03333333333333333 \
 9.076e-09 0.1 \
 9.083928571428572e-09 0.1 \
 9.084928571428572e-09 -0.1 \
 9.092857142857142e-09 -0.1 \
 9.093857142857142e-09 0.1 \
 9.101785714285714e-09 0.1 \
 9.102785714285714e-09 0.1 \
 9.110714285714286e-09 0.1 \
 9.111714285714285e-09 -0.1 \
 9.119642857142858e-09 -0.1 \
 9.120642857142857e-09 -0.03333333333333333 \
 9.128571428571428e-09 -0.03333333333333333 \
 9.129571428571428e-09 -0.1 \
 9.1375e-09 -0.1 \
 9.138499999999999e-09 -0.1 \
 9.146428571428572e-09 -0.1 \
 9.147428571428571e-09 -0.1 \
 9.155357142857144e-09 -0.1 \
 9.156357142857143e-09 -0.1 \
 9.164285714285714e-09 -0.1 \
 9.165285714285713e-09 -0.1 \
 9.173214285714286e-09 -0.1 \
 9.174214285714285e-09 0.03333333333333333 \
 9.182142857142858e-09 0.03333333333333333 \
 9.183142857142857e-09 0.03333333333333333 \
 9.191071428571428e-09 0.03333333333333333 \
 9.192071428571427e-09 -0.03333333333333333 \
 9.2e-09 -0.03333333333333333 \
 9.200999999999999e-09 0.03333333333333333 \
 9.208928571428572e-09 0.03333333333333333 \
 9.209928571428571e-09 0.03333333333333333 \
 9.217857142857143e-09 0.03333333333333333 \
 9.218857142857143e-09 0.1 \
 9.226785714285714e-09 0.1 \
 9.227785714285713e-09 -0.1 \
 9.235714285714285e-09 -0.1 \
 9.236714285714285e-09 -0.03333333333333333 \
 9.244642857142857e-09 -0.03333333333333333 \
 9.245642857142857e-09 0.03333333333333333 \
 9.253571428571429e-09 0.03333333333333333 \
 9.254571428571429e-09 0.1 \
 9.262499999999999e-09 0.1 \
 9.263499999999999e-09 0.03333333333333333 \
 9.271428571428571e-09 0.03333333333333333 \
 9.272428571428571e-09 -0.03333333333333333 \
 9.280357142857143e-09 -0.03333333333333333 \
 9.281357142857143e-09 0.1 \
 9.289285714285715e-09 0.1 \
 9.290285714285714e-09 0.03333333333333333 \
 9.298214285714285e-09 0.03333333333333333 \
 9.299214285714285e-09 0.1 \
 9.307142857142857e-09 0.1 \
 9.308142857142857e-09 -0.03333333333333333 \
 9.316071428571429e-09 -0.03333333333333333 \
 9.317071428571428e-09 0.03333333333333333 \
 9.325000000000001e-09 0.03333333333333333 \
 9.326e-09 -0.03333333333333333 \
 9.333928571428571e-09 -0.03333333333333333 \
 9.33492857142857e-09 0.1 \
 9.342857142857143e-09 0.1 \
 9.343857142857142e-09 0.03333333333333333 \
 9.351785714285715e-09 0.03333333333333333 \
 9.352785714285714e-09 -0.1 \
 9.360714285714285e-09 -0.1 \
 9.361714285714284e-09 0.1 \
 9.369642857142857e-09 0.1 \
 9.370642857142856e-09 -0.1 \
 9.378571428571429e-09 -0.1 \
 9.379571428571428e-09 0.03333333333333333 \
 9.387500000000001e-09 0.03333333333333333 \
 9.3885e-09 0.03333333333333333 \
 9.396428571428571e-09 0.03333333333333333 \
 9.39742857142857e-09 -0.1 \
 9.405357142857143e-09 -0.1 \
 9.406357142857142e-09 0.03333333333333333 \
 9.414285714285714e-09 0.03333333333333333 \
 9.415285714285714e-09 0.03333333333333333 \
 9.423214285714286e-09 0.03333333333333333 \
 9.424214285714286e-09 -0.03333333333333333 \
 9.432142857142857e-09 -0.03333333333333333 \
 9.433142857142856e-09 -0.03333333333333333 \
 9.441071428571428e-09 -0.03333333333333333 \
 9.442071428571428e-09 -0.1 \
 9.45e-09 -0.1 \
 9.451e-09 0.1 \
 9.458928571428572e-09 0.1 \
 9.459928571428572e-09 -0.03333333333333333 \
 9.467857142857142e-09 -0.03333333333333333 \
 9.468857142857142e-09 0.03333333333333333 \
 9.476785714285714e-09 0.03333333333333333 \
 9.477785714285714e-09 -0.03333333333333333 \
 9.485714285714286e-09 -0.03333333333333333 \
 9.486714285714286e-09 -0.1 \
 9.494642857142858e-09 -0.1 \
 9.495642857142857e-09 -0.1 \
 9.503571428571428e-09 -0.1 \
 9.504571428571428e-09 0.1 \
 9.5125e-09 0.1 \
 9.513499999999999e-09 0.1 \
 9.521428571428572e-09 0.1 \
 9.522428571428571e-09 -0.03333333333333333 \
 9.530357142857142e-09 -0.03333333333333333 \
 9.531357142857142e-09 -0.1 \
 9.539285714285714e-09 -0.1 \
 9.540285714285713e-09 0.03333333333333333 \
 9.548214285714286e-09 0.03333333333333333 \
 9.549214285714285e-09 -0.1 \
 9.557142857142858e-09 -0.1 \
 9.558142857142857e-09 0.03333333333333333 \
 9.566071428571428e-09 0.03333333333333333 \
 9.567071428571427e-09 -0.03333333333333333 \
 9.575e-09 -0.03333333333333333 \
 9.575999999999999e-09 0.03333333333333333 \
 9.583928571428572e-09 0.03333333333333333 \
 9.584928571428571e-09 -0.03333333333333333 \
 9.592857142857143e-09 -0.03333333333333333 \
 9.593857142857143e-09 0.1 \
 9.601785714285714e-09 0.1 \
 9.602785714285713e-09 -0.1 \
 9.610714285714286e-09 -0.1 \
 9.611714285714285e-09 0.03333333333333333 \
 9.619642857142857e-09 0.03333333333333333 \
 9.620642857142857e-09 -0.03333333333333333 \
 9.628571428571429e-09 -0.03333333333333333 \
 9.629571428571429e-09 -0.1 \
 9.637499999999999e-09 -0.1 \
 9.638499999999999e-09 -0.1 \
 9.646428571428571e-09 -0.1 \
 9.647428571428571e-09 -0.03333333333333333 \
 9.655357142857143e-09 -0.03333333333333333 \
 9.656357142857143e-09 0.03333333333333333 \
 9.664285714285715e-09 0.03333333333333333 \
 9.665285714285715e-09 0.1 \
 9.673214285714285e-09 0.1 \
 9.674214285714285e-09 -0.1 \
 9.682142857142857e-09 -0.1 \
 9.683142857142857e-09 -0.1 \
 9.691071428571429e-09 -0.1 \
 9.692071428571428e-09 -0.1 \
 9.699999999999999e-09 -0.1 \
 9.700999999999999e-09 0.1 \
 9.708928571428571e-09 0.1 \
 9.709928571428571e-09 -0.1 \
 9.717857142857143e-09 -0.1 \
 9.718857142857142e-09 -0.1 \
 9.726785714285715e-09 -0.1 \
 9.727785714285714e-09 0.1 \
 9.735714285714285e-09 0.1 \
 9.736714285714284e-09 0.03333333333333333 \
 9.744642857142857e-09 0.03333333333333333 \
 9.745642857142856e-09 0.03333333333333333 \
 9.753571428571429e-09 0.03333333333333333 \
 9.754571428571428e-09 -0.1 \
 9.762500000000001e-09 -0.1 \
 9.7635e-09 -0.1 \
 9.771428571428571e-09 -0.1 \
 9.77242857142857e-09 -0.1 \
 9.780357142857143e-09 -0.1 \
 9.781357142857142e-09 -0.03333333333333333 \
 9.789285714285714e-09 -0.03333333333333333 \
 9.790285714285714e-09 0.03333333333333333 \
 9.798214285714286e-09 0.03333333333333333 \
 9.799214285714286e-09 -0.1 \
 9.807142857142857e-09 -0.1 \
 9.808142857142856e-09 -0.1 \
 9.816071428571428e-09 -0.1 \
 9.817071428571428e-09 -0.1 \
 9.825e-09 -0.1 \
 9.826e-09 0.1 \
 9.833928571428572e-09 0.1 \
 9.834928571428572e-09 0.03333333333333333 \
 9.842857142857142e-09 0.03333333333333333 \
 9.843857142857142e-09 0.1 \
 9.851785714285714e-09 0.1 \
 9.852785714285714e-09 -0.03333333333333333 \
 9.860714285714286e-09 -0.03333333333333333 \
 9.861714285714286e-09 -0.03333333333333333 \
 9.869642857142858e-09 -0.03333333333333333 \
 9.870642857142857e-09 0.1 \
 9.878571428571428e-09 0.1 \
 9.879571428571428e-09 -0.03333333333333333 \
 9.8875e-09 -0.03333333333333333 \
 9.8885e-09 0.03333333333333333 \
 9.896428571428572e-09 0.03333333333333333 \
 9.897428571428571e-09 0.03333333333333333 \
 9.905357142857142e-09 0.03333333333333333 \
 9.906357142857142e-09 0.03333333333333333 \
 9.914285714285714e-09 0.03333333333333333 \
 9.915285714285713e-09 0.03333333333333333 \
 9.923214285714286e-09 0.03333333333333333 \
 9.924214285714285e-09 -0.03333333333333333 \
 9.932142857142858e-09 -0.03333333333333333 \
 9.933142857142857e-09 0.03333333333333333 \
 9.941071428571428e-09 0.03333333333333333 \
 9.942071428571427e-09 0.03333333333333333 \
 9.95e-09 0.03333333333333333 \
 9.950999999999999e-09 0.1 \
 9.958928571428572e-09 0.1 \
 9.959928571428571e-09 0.1 \
 9.967857142857143e-09 0.1 \
 9.968857142857143e-09 0.1 \
 9.976785714285714e-09 0.1 \
 9.977785714285713e-09 0.03333333333333333 \
 9.985714285714286e-09 0.03333333333333333 \
 9.986714285714285e-09 0.1 \
 9.994642857142857e-09 0.1 \
 9.995642857142857e-09 -0.1 \
 1.000357142857143e-08 -0.1 \
 1.000457142857143e-08 0.1 \
 1.00125e-08 0.1 \
 1.00135e-08 -0.03333333333333333 \
 1.002142857142857e-08 -0.03333333333333333 \
 1.002242857142857e-08 -0.03333333333333333 \
 1.003035714285714e-08 -0.03333333333333333 \
 1.003135714285714e-08 -0.03333333333333333 \
 1.003928571428572e-08 -0.03333333333333333 \
 1.004028571428571e-08 0.1 \
 1.004821428571429e-08 0.1 \
 1.004921428571428e-08 -0.1 \
 1.005714285714286e-08 -0.1 \
 1.005814285714286e-08 0.1 \
 1.006607142857143e-08 0.1 \
 1.006707142857143e-08 -0.1 \
 1.0075e-08 -0.1 \
 1.0076e-08 0.1 \
 1.008392857142857e-08 0.1 \
 1.008492857142857e-08 0.03333333333333333 \
 1.009285714285714e-08 0.03333333333333333 \
 1.009385714285714e-08 0.03333333333333333 \
 1.010178571428571e-08 0.03333333333333333 \
 1.010278571428571e-08 -0.03333333333333333 \
 1.011071428571429e-08 -0.03333333333333333 \
 1.011171428571428e-08 0.1 \
 1.011964285714286e-08 0.1 \
 1.012064285714286e-08 0.1 \
 1.012857142857143e-08 0.1 \
 1.012957142857143e-08 -0.03333333333333333 \
 1.01375e-08 -0.03333333333333333 \
 1.01385e-08 0.03333333333333333 \
 1.014642857142857e-08 0.03333333333333333 \
 1.014742857142857e-08 0.1 \
 1.015535714285714e-08 0.1 \
 1.015635714285714e-08 -0.03333333333333333 \
 1.016428571428571e-08 -0.03333333333333333 \
 1.016528571428571e-08 -0.03333333333333333 \
 1.017321428571429e-08 -0.03333333333333333 \
 1.017421428571429e-08 -0.03333333333333333 \
 1.018214285714286e-08 -0.03333333333333333 \
 1.018314285714286e-08 -0.1 \
 1.019107142857143e-08 -0.1 \
 1.019207142857143e-08 -0.1 \
 1.02e-08 -0.1 \
 1.0201e-08 0.03333333333333333 \
 1.020892857142857e-08 0.03333333333333333 \
 1.020992857142857e-08 0.03333333333333333 \
 1.021785714285714e-08 0.03333333333333333 \
 1.021885714285714e-08 0.03333333333333333 \
 1.022678571428571e-08 0.03333333333333333 \
 1.022778571428571e-08 0.03333333333333333 \
 1.023571428571429e-08 0.03333333333333333 \
 1.023671428571429e-08 0.03333333333333333 \
 1.024464285714286e-08 0.03333333333333333 \
 1.024564285714286e-08 0.1 \
 1.025357142857143e-08 0.1 \
 1.025457142857143e-08 0.03333333333333333 \
 1.02625e-08 0.03333333333333333 \
 1.02635e-08 0.1 \
 1.027142857142857e-08 0.1 \
 1.027242857142857e-08 -0.1 \
 1.028035714285714e-08 -0.1 \
 1.028135714285714e-08 -0.1 \
 1.028928571428571e-08 -0.1 \
 1.029028571428571e-08 -0.1 \
 1.029821428571429e-08 -0.1 \
 1.029921428571429e-08 -0.03333333333333333 \
 1.030714285714286e-08 -0.03333333333333333 \
 1.030814285714286e-08 -0.03333333333333333 \
 1.031607142857143e-08 -0.03333333333333333 \
 1.031707142857143e-08 0.1 \
 1.0325e-08 0.1 \
 1.0326e-08 -0.1 \
 1.033392857142857e-08 -0.1 \
 1.033492857142857e-08 0.1 \
 1.034285714285714e-08 0.1 \
 1.034385714285714e-08 0.03333333333333333 \
 1.035178571428571e-08 0.03333333333333333 \
 1.035278571428571e-08 -0.03333333333333333 \
 1.036071428571429e-08 -0.03333333333333333 \
 1.036171428571429e-08 0.03333333333333333 \
 1.036964285714286e-08 0.03333333333333333 \
 1.037064285714286e-08 0.03333333333333333 \
 1.037857142857143e-08 0.03333333333333333 \
 1.037957142857143e-08 0.03333333333333333 \
 1.03875e-08 0.03333333333333333 \
 1.03885e-08 0.03333333333333333 \
 1.039642857142857e-08 0.03333333333333333 \
 1.039742857142857e-08 -0.1 \
 1.040535714285714e-08 -0.1 \
 1.040635714285714e-08 -0.1 \
 1.041428571428571e-08 -0.1 \
 1.041528571428571e-08 -0.1 \
 1.042321428571429e-08 -0.1 \
 1.042421428571428e-08 -0.1 \
 1.043214285714286e-08 -0.1 \
 1.043314285714286e-08 -0.03333333333333333 \
 1.044107142857143e-08 -0.03333333333333333 \
 1.044207142857143e-08 0.03333333333333333 \
 1.045e-08 0.03333333333333333 \
 1.0451e-08 -0.1 \
 1.045892857142857e-08 -0.1 \
 1.045992857142857e-08 -0.03333333333333333 \
 1.046785714285714e-08 -0.03333333333333333 \
 1.046885714285714e-08 0.1 \
 1.047678571428571e-08 0.1 \
 1.047778571428571e-08 0.03333333333333333 \
 1.048571428571429e-08 0.03333333333333333 \
 1.048671428571428e-08 -0.03333333333333333 \
 1.049464285714286e-08 -0.03333333333333333 \
 1.049564285714286e-08 -0.03333333333333333 \
 1.050357142857143e-08 -0.03333333333333333 \
 1.050457142857143e-08 0.03333333333333333 \
 1.05125e-08 0.03333333333333333 \
 1.05135e-08 -0.1 \
 1.052142857142857e-08 -0.1 \
 1.052242857142857e-08 0.1 \
 1.053035714285714e-08 0.1 \
 1.053135714285714e-08 0.03333333333333333 \
 1.053928571428571e-08 0.03333333333333333 \
 1.054028571428571e-08 -0.03333333333333333 \
 1.054821428571429e-08 -0.03333333333333333 \
 1.054921428571429e-08 0.1 \
 1.055714285714286e-08 0.1 \
 1.055814285714286e-08 0.03333333333333333 \
 1.056607142857143e-08 0.03333333333333333 \
 1.056707142857143e-08 0.1 \
 1.0575e-08 0.1 \
 1.0576e-08 0.1 \
 1.058392857142857e-08 0.1 \
 1.058492857142857e-08 -0.1 \
 1.059285714285714e-08 -0.1 \
 1.059385714285714e-08 -0.03333333333333333 \
 1.060178571428571e-08 -0.03333333333333333 \
 1.060278571428571e-08 0.1 \
 1.061071428571429e-08 0.1 \
 1.061171428571429e-08 0.1 \
 1.061964285714286e-08 0.1 \
 1.062064285714286e-08 0.1 \
 1.062857142857143e-08 0.1 \
 1.062957142857143e-08 0.03333333333333333 \
 1.06375e-08 0.03333333333333333 \
 1.06385e-08 -0.03333333333333333 \
 1.064642857142857e-08 -0.03333333333333333 \
 1.064742857142857e-08 -0.1 \
 1.065535714285714e-08 -0.1 \
 1.065635714285714e-08 -0.1 \
 1.066428571428571e-08 -0.1 \
 1.066528571428571e-08 0.03333333333333333 \
 1.067321428571429e-08 0.03333333333333333 \
 1.067421428571429e-08 0.03333333333333333 \
 1.068214285714286e-08 0.03333333333333333 \
 1.068314285714286e-08 -0.03333333333333333 \
 1.069107142857143e-08 -0.03333333333333333 \
 1.069207142857143e-08 0.03333333333333333 \
 1.07e-08 0.03333333333333333 \
 1.0701e-08 -0.03333333333333333 \
 1.070892857142857e-08 -0.03333333333333333 \
 1.070992857142857e-08 0.03333333333333333 \
 1.071785714285714e-08 0.03333333333333333 \
 1.071885714285714e-08 0.1 \
 1.072678571428571e-08 0.1 \
 1.072778571428571e-08 0.1 \
 1.073571428571429e-08 0.1 \
 1.073671428571429e-08 -0.1 \
 1.074464285714286e-08 -0.1 \
 1.074564285714286e-08 -0.03333333333333333 \
 1.075357142857143e-08 -0.03333333333333333 \
 1.075457142857143e-08 -0.03333333333333333 \
 1.07625e-08 -0.03333333333333333 \
 1.07635e-08 -0.1 \
 1.077142857142857e-08 -0.1 \
 1.077242857142857e-08 0.03333333333333333 \
 1.078035714285714e-08 0.03333333333333333 \
 1.078135714285714e-08 0.03333333333333333 \
 1.078928571428571e-08 0.03333333333333333 \
 1.079028571428571e-08 0.1 \
 1.079821428571429e-08 0.1 \
 1.079921428571428e-08 -0.1 \
 1.080714285714286e-08 -0.1 \
 1.080814285714286e-08 -0.03333333333333333 \
 1.081607142857143e-08 -0.03333333333333333 \
 1.081707142857143e-08 -0.1 \
 1.0825e-08 -0.1 \
 1.0826e-08 -0.1 \
 1.083392857142857e-08 -0.1 \
 1.083492857142857e-08 0.1 \
 1.084285714285714e-08 0.1 \
 1.084385714285714e-08 -0.03333333333333333 \
 1.085178571428571e-08 -0.03333333333333333 \
 1.085278571428571e-08 0.03333333333333333 \
 1.086071428571429e-08 0.03333333333333333 \
 1.086171428571428e-08 -0.03333333333333333 \
 1.086964285714286e-08 -0.03333333333333333 \
 1.087064285714286e-08 0.03333333333333333 \
 1.087857142857143e-08 0.03333333333333333 \
 1.087957142857143e-08 -0.1 \
 1.08875e-08 -0.1 \
 1.08885e-08 0.1 \
 1.089642857142857e-08 0.1 \
 1.089742857142857e-08 -0.1 \
 1.090535714285714e-08 -0.1 \
 1.090635714285714e-08 0.1 \
 1.091428571428571e-08 0.1 \
 1.091528571428571e-08 -0.03333333333333333 \
 1.092321428571429e-08 -0.03333333333333333 \
 1.092421428571429e-08 0.1 \
 1.093214285714286e-08 0.1 \
 1.093314285714286e-08 -0.1 \
 1.094107142857143e-08 -0.1 \
 1.094207142857143e-08 -0.03333333333333333 \
 1.095e-08 -0.03333333333333333 \
 1.0951e-08 -0.03333333333333333 \
 1.095892857142857e-08 -0.03333333333333333 \
 1.095992857142857e-08 -0.1 \
 1.096785714285714e-08 -0.1 \
 1.096885714285714e-08 0.03333333333333333 \
 1.097678571428571e-08 0.03333333333333333 \
 1.097778571428571e-08 0.03333333333333333 \
 1.098571428571429e-08 0.03333333333333333 \
 1.098671428571429e-08 -0.1 \
 1.099464285714286e-08 -0.1 \
 1.099564285714286e-08 0.03333333333333333 \
 1.100357142857143e-08 0.03333333333333333 \
 1.100457142857143e-08 -0.1 \
 1.10125e-08 -0.1 \
 1.10135e-08 -0.1 \
 1.102142857142857e-08 -0.1 \
 1.102242857142857e-08 0.03333333333333333 \
 1.103035714285714e-08 0.03333333333333333 \
 1.103135714285714e-08 -0.1 \
 1.103928571428571e-08 -0.1 \
 1.104028571428571e-08 0.03333333333333333 \
 1.104821428571429e-08 0.03333333333333333 \
 1.104921428571429e-08 0.03333333333333333 \
 1.105714285714286e-08 0.03333333333333333 \
 1.105814285714286e-08 0.1 \
 1.106607142857143e-08 0.1 \
 1.106707142857143e-08 0.1 \
 1.1075e-08 0.1 \
 1.1076e-08 0.1 \
 1.108392857142857e-08 0.1 \
 1.108492857142857e-08 0.1 \
 1.109285714285714e-08 0.1 \
 1.109385714285714e-08 -0.1 \
 1.110178571428571e-08 -0.1 \
 1.110278571428571e-08 0.1 \
 1.111071428571429e-08 0.1 \
 1.111171428571429e-08 -0.03333333333333333 \
 1.111964285714286e-08 -0.03333333333333333 \
 1.112064285714286e-08 -0.03333333333333333 \
 1.112857142857143e-08 -0.03333333333333333 \
 1.112957142857143e-08 0.03333333333333333 \
 1.11375e-08 0.03333333333333333 \
 1.11385e-08 0.1 \
 1.114642857142857e-08 0.1 \
 1.114742857142857e-08 -0.03333333333333333 \
 1.115535714285714e-08 -0.03333333333333333 \
 1.115635714285714e-08 0.03333333333333333 \
 1.116428571428571e-08 0.03333333333333333 \
 1.116528571428571e-08 -0.03333333333333333 \
 1.117321428571429e-08 -0.03333333333333333 \
 1.117421428571428e-08 -0.1 \
 1.118214285714286e-08 -0.1 \
 1.118314285714286e-08 -0.03333333333333333 \
 1.119107142857143e-08 -0.03333333333333333 \
 1.119207142857143e-08 -0.1 \
 1.12e-08 -0.1 \
 1.1201e-08 -0.1 \
 1.120892857142857e-08 -0.1 \
 1.120992857142857e-08 0.1 \
 1.121785714285714e-08 0.1 \
 1.121885714285714e-08 -0.1 \
 1.122678571428571e-08 -0.1 \
 1.122778571428571e-08 -0.1 \
 1.123571428571429e-08 -0.1 \
 1.123671428571428e-08 -0.1 \
 1.124464285714286e-08 -0.1 \
 1.124564285714286e-08 -0.1 \
 1.125357142857143e-08 -0.1 \
 1.125457142857143e-08 -0.1 \
 1.12625e-08 -0.1 \
 1.12635e-08 -0.03333333333333333 \
 1.127142857142857e-08 -0.03333333333333333 \
 1.127242857142857e-08 0.03333333333333333 \
 1.128035714285714e-08 0.03333333333333333 \
 1.128135714285714e-08 -0.1 \
 1.128928571428571e-08 -0.1 \
 1.129028571428571e-08 -0.03333333333333333 \
 1.129821428571428e-08 -0.03333333333333333 \
 1.129921428571428e-08 -0.03333333333333333 \
 1.130714285714286e-08 -0.03333333333333333 \
 1.130814285714286e-08 -0.1 \
 1.131607142857143e-08 -0.1 \
 1.131707142857143e-08 0.03333333333333333 \
 1.1325e-08 0.03333333333333333 \
 1.1326e-08 -0.1 \
 1.133392857142857e-08 -0.1 \
 1.133492857142857e-08 -0.03333333333333333 \
 1.134285714285714e-08 -0.03333333333333333 \
 1.134385714285714e-08 0.1 \
 1.135178571428571e-08 0.1 \
 1.135278571428571e-08 0.1 \
 1.136071428571429e-08 0.1 \
 1.136171428571429e-08 0.1 \
 1.136964285714286e-08 0.1 \
 1.137064285714286e-08 -0.1 \
 1.137857142857143e-08 -0.1 \
 1.137957142857143e-08 0.1 \
 1.13875e-08 0.1 \
 1.13885e-08 -0.1 \
 1.139642857142857e-08 -0.1 \
 1.139742857142857e-08 -0.03333333333333333 \
 1.140535714285714e-08 -0.03333333333333333 \
 1.140635714285714e-08 -0.1 \
 1.141428571428571e-08 -0.1 \
 1.141528571428571e-08 0.03333333333333333 \
 1.142321428571429e-08 0.03333333333333333 \
 1.142421428571429e-08 0.03333333333333333 \
 1.143214285714286e-08 0.03333333333333333 \
 1.143314285714286e-08 0.03333333333333333 \
 1.144107142857143e-08 0.03333333333333333 \
 1.144207142857143e-08 0.03333333333333333 \
 1.145e-08 0.03333333333333333 \
 1.1451e-08 0.1 \
 1.145892857142857e-08 0.1 \
 1.145992857142857e-08 -0.1 \
 1.146785714285714e-08 -0.1 \
 1.146885714285714e-08 0.1 \
 1.147678571428571e-08 0.1 \
 1.147778571428571e-08 0.1 \
 1.148571428571429e-08 0.1 \
 1.148671428571429e-08 0.1 \
 1.149464285714286e-08 0.1 \
 1.149564285714286e-08 0.1 \
 1.150357142857143e-08 0.1 \
 1.150457142857143e-08 0.1 \
 1.15125e-08 0.1 \
 1.15135e-08 0.1 \
 1.152142857142857e-08 0.1 \
 1.152242857142857e-08 0.1 \
 1.153035714285714e-08 0.1 \
 1.153135714285714e-08 0.1 \
 1.153928571428571e-08 0.1 \
 1.154028571428571e-08 0.03333333333333333 \
 1.154821428571429e-08 0.03333333333333333 \
 1.154921428571428e-08 -0.03333333333333333 \
 1.155714285714286e-08 -0.03333333333333333 \
 1.155814285714286e-08 0.1 \
 1.156607142857143e-08 0.1 \
 1.156707142857143e-08 0.03333333333333333 \
 1.1575e-08 0.03333333333333333 \
 1.1576e-08 0.03333333333333333 \
 1.158392857142857e-08 0.03333333333333333 \
 1.158492857142857e-08 0.03333333333333333 \
 1.159285714285714e-08 0.03333333333333333 \
 1.159385714285714e-08 -0.1 \
 1.160178571428572e-08 -0.1 \
 1.160278571428571e-08 0.1 \
 1.161071428571429e-08 0.1 \
 1.161171428571428e-08 -0.03333333333333333 \
 1.161964285714286e-08 -0.03333333333333333 \
 1.162064285714286e-08 0.03333333333333333 \
 1.162857142857143e-08 0.03333333333333333 \
 1.162957142857143e-08 -0.1 \
 1.16375e-08 -0.1 \
 1.16385e-08 -0.1 \
 1.164642857142857e-08 -0.1 \
 1.164742857142857e-08 0.03333333333333333 \
 1.165535714285714e-08 0.03333333333333333 \
 1.165635714285714e-08 -0.03333333333333333 \
 1.166428571428571e-08 -0.03333333333333333 \
 1.166528571428571e-08 -0.03333333333333333 \
 1.167321428571428e-08 -0.03333333333333333 \
 1.167421428571428e-08 0.03333333333333333 \
 1.168214285714286e-08 0.03333333333333333 \
 1.168314285714286e-08 -0.1 \
 1.169107142857143e-08 -0.1 \
 1.169207142857143e-08 -0.03333333333333333 \
 1.17e-08 -0.03333333333333333 \
 1.1701e-08 -0.03333333333333333 \
 1.170892857142857e-08 -0.03333333333333333 \
 1.170992857142857e-08 0.03333333333333333 \
 1.171785714285714e-08 0.03333333333333333 \
 1.171885714285714e-08 -0.03333333333333333 \
 1.172678571428571e-08 -0.03333333333333333 \
 1.172778571428571e-08 -0.03333333333333333 \
 1.173571428571429e-08 -0.03333333333333333 \
 1.173671428571429e-08 -0.03333333333333333 \
 1.174464285714286e-08 -0.03333333333333333 \
 1.174564285714286e-08 0.1 \
 1.175357142857143e-08 0.1 \
 1.175457142857143e-08 -0.03333333333333333 \
 1.17625e-08 -0.03333333333333333 \
 1.17635e-08 0.03333333333333333 \
 1.177142857142857e-08 0.03333333333333333 \
 1.177242857142857e-08 0.1 \
 1.178035714285714e-08 0.1 \
 1.178135714285714e-08 -0.03333333333333333 \
 1.178928571428571e-08 -0.03333333333333333 \
 1.179028571428571e-08 0.1 \
 1.179821428571429e-08 0.1 \
 1.179921428571429e-08 0.03333333333333333 \
 1.180714285714286e-08 0.03333333333333333 \
 1.180814285714286e-08 -0.03333333333333333 \
 1.181607142857143e-08 -0.03333333333333333 \
 1.181707142857143e-08 0.03333333333333333 \
 1.1825e-08 0.03333333333333333 \
 1.1826e-08 -0.03333333333333333 \
 1.183392857142857e-08 -0.03333333333333333 \
 1.183492857142857e-08 0.03333333333333333 \
 1.184285714285714e-08 0.03333333333333333 \
 1.184385714285714e-08 -0.1 \
 1.185178571428571e-08 -0.1 \
 1.185278571428571e-08 0.03333333333333333 \
 1.186071428571429e-08 0.03333333333333333 \
 1.186171428571429e-08 -0.03333333333333333 \
 1.186964285714286e-08 -0.03333333333333333 \
 1.187064285714286e-08 0.03333333333333333 \
 1.187857142857143e-08 0.03333333333333333 \
 1.187957142857143e-08 0.03333333333333333 \
 1.18875e-08 0.03333333333333333 \
 1.18885e-08 0.1 \
 1.189642857142857e-08 0.1 \
 1.189742857142857e-08 0.1 \
 1.190535714285714e-08 0.1 \
 1.190635714285714e-08 0.03333333333333333 \
 1.191428571428571e-08 0.03333333333333333 \
 1.191528571428571e-08 0.03333333333333333 \
 1.192321428571429e-08 0.03333333333333333 \
 1.192421428571429e-08 0.03333333333333333 \
 1.193214285714286e-08 0.03333333333333333 \
 1.193314285714286e-08 -0.03333333333333333 \
 1.194107142857143e-08 -0.03333333333333333 \
 1.194207142857143e-08 0.1 \
 1.195e-08 0.1 \
 1.1951e-08 0.1 \
 1.195892857142857e-08 0.1 \
 1.195992857142857e-08 -0.03333333333333333 \
 1.196785714285714e-08 -0.03333333333333333 \
 1.196885714285714e-08 0.1 \
 1.197678571428572e-08 0.1 \
 1.197778571428571e-08 0.03333333333333333 \
 1.198571428571429e-08 0.03333333333333333 \
 1.198671428571428e-08 0.03333333333333333 \
 1.199464285714286e-08 0.03333333333333333 \
 1.199564285714286e-08 -0.03333333333333333 \
 1.200357142857143e-08 -0.03333333333333333 \
 1.200457142857143e-08 -0.03333333333333333 \
 1.20125e-08 -0.03333333333333333 \
 1.20135e-08 -0.03333333333333333 \
 1.202142857142857e-08 -0.03333333333333333 \
 1.202242857142857e-08 0.1 \
 1.203035714285714e-08 0.1 \
 1.203135714285714e-08 0.1 \
 1.203928571428571e-08 0.1 \
 1.204028571428571e-08 -0.03333333333333333 \
 1.204821428571429e-08 -0.03333333333333333 \
 1.204921428571428e-08 -0.1 \
 1.205714285714286e-08 -0.1 \
 1.205814285714286e-08 -0.03333333333333333 \
 1.206607142857143e-08 -0.03333333333333333 \
 1.206707142857143e-08 0.03333333333333333 \
 1.2075e-08 0.03333333333333333 \
 1.2076e-08 0.03333333333333333 \
 1.208392857142857e-08 0.03333333333333333 \
 1.208492857142857e-08 0.03333333333333333 \
 1.209285714285714e-08 0.03333333333333333 \
 1.209385714285714e-08 -0.03333333333333333 \
 1.210178571428571e-08 -0.03333333333333333 \
 1.210278571428571e-08 0.1 \
 1.211071428571429e-08 0.1 \
 1.211171428571429e-08 -0.03333333333333333 \
 1.211964285714286e-08 -0.03333333333333333 \
 1.212064285714286e-08 0.1 \
 1.212857142857143e-08 0.1 \
 1.212957142857143e-08 -0.03333333333333333 \
 1.21375e-08 -0.03333333333333333 \
 1.21385e-08 0.03333333333333333 \
 1.214642857142857e-08 0.03333333333333333 \
 1.214742857142857e-08 -0.1 \
 1.215535714285714e-08 -0.1 \
 1.215635714285714e-08 -0.1 \
 1.216428571428571e-08 -0.1 \
 1.216528571428571e-08 -0.1 \
 1.217321428571429e-08 -0.1 \
 1.217421428571429e-08 0.1 \
 1.218214285714286e-08 0.1 \
 1.218314285714286e-08 -0.1 \
 1.219107142857143e-08 -0.1 \
 1.219207142857143e-08 0.03333333333333333 \
 1.22e-08 0.03333333333333333 \
 1.2201e-08 -0.1 \
 1.220892857142857e-08 -0.1 \
 1.220992857142857e-08 0.1 \
 1.221785714285714e-08 0.1 \
 1.221885714285714e-08 0.1 \
 1.222678571428571e-08 0.1 \
 1.222778571428571e-08 0.03333333333333333 \
 1.223571428571429e-08 0.03333333333333333 \
 1.223671428571429e-08 0.03333333333333333 \
 1.224464285714286e-08 0.03333333333333333 \
 1.224564285714286e-08 -0.03333333333333333 \
 1.225357142857143e-08 -0.03333333333333333 \
 1.225457142857143e-08 0.03333333333333333 \
 1.22625e-08 0.03333333333333333 \
 1.22635e-08 0.03333333333333333 \
 1.227142857142857e-08 0.03333333333333333 \
 1.227242857142857e-08 -0.1 \
 1.228035714285714e-08 -0.1 \
 1.228135714285714e-08 -0.1 \
 1.228928571428571e-08 -0.1 \
 1.229028571428571e-08 0.1 \
 1.229821428571429e-08 0.1 \
 1.229921428571429e-08 0.03333333333333333 \
 1.230714285714286e-08 0.03333333333333333 \
 1.230814285714286e-08 -0.03333333333333333 \
 1.231607142857143e-08 -0.03333333333333333 \
 1.231707142857143e-08 -0.1 \
 1.2325e-08 -0.1 \
 1.2326e-08 -0.03333333333333333 \
 1.233392857142857e-08 -0.03333333333333333 \
 1.233492857142857e-08 -0.03333333333333333 \
 1.234285714285714e-08 -0.03333333333333333 \
 1.234385714285714e-08 0.1 \
 1.235178571428571e-08 0.1 \
 1.235278571428571e-08 -0.03333333333333333 \
 1.236071428571429e-08 -0.03333333333333333 \
 1.236171428571428e-08 0.03333333333333333 \
 1.236964285714286e-08 0.03333333333333333 \
 1.237064285714286e-08 0.03333333333333333 \
 1.237857142857143e-08 0.03333333333333333 \
 1.237957142857143e-08 0.1 \
 1.23875e-08 0.1 \
 1.23885e-08 -0.03333333333333333 \
 1.239642857142857e-08 -0.03333333333333333 \
 1.239742857142857e-08 0.1 \
 1.240535714285714e-08 0.1 \
 1.240635714285714e-08 0.1 \
 1.241428571428571e-08 0.1 \
 1.241528571428571e-08 0.1 \
 1.242321428571429e-08 0.1 \
 1.242421428571428e-08 0.03333333333333333 \
 1.243214285714286e-08 0.03333333333333333 \
 1.243314285714286e-08 0.1 \
 1.244107142857143e-08 0.1 \
 1.244207142857143e-08 0.1 \
 1.245e-08 0.1 \
 1.2451e-08 0.1 \
 1.245892857142857e-08 0.1 \
 1.245992857142857e-08 0.03333333333333333 \
 1.246785714285714e-08 0.03333333333333333 \
 1.246885714285714e-08 -0.1 \
 1.247678571428571e-08 -0.1 \
 1.247778571428571e-08 -0.1 \
 1.248571428571429e-08 -0.1 \
 1.248671428571429e-08 -0.03333333333333333 \
 1.249464285714286e-08 -0.03333333333333333 \
 1.249564285714286e-08 -0.1 \
 1.250357142857143e-08 -0.1 \
 1.250457142857143e-08 0.03333333333333333 \
 1.25125e-08 0.03333333333333333 \
 1.25135e-08 -0.03333333333333333 \
 1.252142857142857e-08 -0.03333333333333333 \
 1.252242857142857e-08 -0.03333333333333333 \
 1.253035714285714e-08 -0.03333333333333333 \
 1.253135714285714e-08 -0.1 \
 1.253928571428571e-08 -0.1 \
 1.254028571428571e-08 -0.1 \
 1.254821428571429e-08 -0.1 \
 1.254921428571429e-08 0.03333333333333333 \
 1.255714285714286e-08 0.03333333333333333 \
 1.255814285714286e-08 0.03333333333333333 \
 1.256607142857143e-08 0.03333333333333333 \
 1.256707142857143e-08 0.03333333333333333 \
 1.2575e-08 0.03333333333333333 \
 1.2576e-08 0.1 \
 1.258392857142857e-08 0.1 \
 1.258492857142857e-08 0.1 \
 1.259285714285714e-08 0.1 \
 1.259385714285714e-08 0.1 \
 1.260178571428571e-08 0.1 \
 1.260278571428571e-08 -0.1 \
 1.261071428571429e-08 -0.1 \
 1.261171428571429e-08 -0.1 \
 1.261964285714286e-08 -0.1 \
 1.262064285714286e-08 0.03333333333333333 \
 1.262857142857143e-08 0.03333333333333333 \
 1.262957142857143e-08 -0.03333333333333333 \
 1.26375e-08 -0.03333333333333333 \
 1.26385e-08 -0.1 \
 1.264642857142857e-08 -0.1 \
 1.264742857142857e-08 0.03333333333333333 \
 1.265535714285714e-08 0.03333333333333333 \
 1.265635714285714e-08 -0.1 \
 1.266428571428571e-08 -0.1 \
 1.266528571428571e-08 0.1 \
 1.267321428571429e-08 0.1 \
 1.267421428571429e-08 0.1 \
 1.268214285714286e-08 0.1 \
 1.268314285714286e-08 0.03333333333333333 \
 1.269107142857143e-08 0.03333333333333333 \
 1.269207142857143e-08 0.1 \
 1.27e-08 0.1 \
 1.2701e-08 0.03333333333333333 \
 1.270892857142857e-08 0.03333333333333333 \
 1.270992857142857e-08 0.1 \
 1.271785714285714e-08 0.1 \
 1.271885714285714e-08 0.03333333333333333 \
 1.272678571428571e-08 0.03333333333333333 \
 1.272778571428571e-08 -0.03333333333333333 \
 1.273571428571429e-08 -0.03333333333333333 \
 1.273671428571428e-08 0.1 \
 1.274464285714286e-08 0.1 \
 1.274564285714286e-08 -0.1 \
 1.275357142857143e-08 -0.1 \
 1.275457142857143e-08 -0.03333333333333333 \
 1.27625e-08 -0.03333333333333333 \
 1.27635e-08 -0.1 \
 1.277142857142857e-08 -0.1 \
 1.277242857142857e-08 -0.1 \
 1.278035714285714e-08 -0.1 \
 1.278135714285714e-08 -0.1 \
 1.278928571428571e-08 -0.1 \
 1.279028571428571e-08 0.1 \
 1.279821428571429e-08 0.1 \
 1.279921428571428e-08 0.1 \
 1.280714285714286e-08 0.1 \
 1.280814285714286e-08 0.03333333333333333 \
 1.281607142857143e-08 0.03333333333333333 \
 1.281707142857143e-08 0.1 \
 1.2825e-08 0.1 \
 1.2826e-08 -0.03333333333333333 \
 1.283392857142857e-08 -0.03333333333333333 \
 1.283492857142857e-08 -0.1 \
 1.284285714285714e-08 -0.1 \
 1.284385714285714e-08 0.1 \
 1.285178571428571e-08 0.1 \
 1.285278571428571e-08 0.03333333333333333 \
 1.286071428571428e-08 0.03333333333333333 \
 1.286171428571428e-08 0.1 \
 1.286964285714286e-08 0.1 \
 1.287064285714286e-08 0.03333333333333333 \
 1.287857142857143e-08 0.03333333333333333 \
 1.287957142857143e-08 -0.03333333333333333 \
 1.28875e-08 -0.03333333333333333 \
 1.28885e-08 -0.1 \
 1.289642857142857e-08 -0.1 \
 1.289742857142857e-08 -0.1 \
 1.290535714285714e-08 -0.1 \
 1.290635714285714e-08 0.03333333333333333 \
 1.291428571428571e-08 0.03333333333333333 \
 1.291528571428571e-08 -0.03333333333333333 \
 1.292321428571429e-08 -0.03333333333333333 \
 1.292421428571429e-08 0.03333333333333333 \
 1.293214285714286e-08 0.03333333333333333 \
 1.293314285714286e-08 0.1 \
 1.294107142857143e-08 0.1 \
 1.294207142857143e-08 0.03333333333333333 \
 1.295e-08 0.03333333333333333 \
 1.2951e-08 0.1 \
 1.295892857142857e-08 0.1 \
 1.295992857142857e-08 0.03333333333333333 \
 1.296785714285714e-08 0.03333333333333333 \
 1.296885714285714e-08 0.03333333333333333 \
 1.297678571428571e-08 0.03333333333333333 \
 1.297778571428571e-08 -0.1 \
 1.298571428571429e-08 -0.1 \
 1.298671428571429e-08 0.03333333333333333 \
 1.299464285714286e-08 0.03333333333333333 \
 1.299564285714286e-08 -0.03333333333333333 \
 1.300357142857143e-08 -0.03333333333333333 \
 1.300457142857143e-08 -0.1 \
 1.30125e-08 -0.1 \
 1.30135e-08 -0.03333333333333333 \
 1.302142857142857e-08 -0.03333333333333333 \
 1.302242857142857e-08 -0.1 \
 1.303035714285714e-08 -0.1 \
 1.303135714285714e-08 0.1 \
 1.303928571428571e-08 0.1 \
 1.304028571428571e-08 0.03333333333333333 \
 1.304821428571429e-08 0.03333333333333333 \
 1.304921428571429e-08 -0.03333333333333333 \
 1.305714285714286e-08 -0.03333333333333333 \
 1.305814285714286e-08 -0.1 \
 1.306607142857143e-08 -0.1 \
 1.306707142857143e-08 -0.03333333333333333 \
 1.3075e-08 -0.03333333333333333 \
 1.3076e-08 -0.1 \
 1.308392857142857e-08 -0.1 \
 1.308492857142857e-08 0.03333333333333333 \
 1.309285714285714e-08 0.03333333333333333 \
 1.309385714285714e-08 0.03333333333333333 \
 1.310178571428571e-08 0.03333333333333333 \
 1.310278571428571e-08 -0.03333333333333333 \
 1.311071428571429e-08 -0.03333333333333333 \
 1.311171428571428e-08 -0.03333333333333333 \
 1.311964285714286e-08 -0.03333333333333333 \
 1.312064285714286e-08 -0.1 \
 1.312857142857143e-08 -0.1 \
 1.312957142857143e-08 0.1 \
 1.31375e-08 0.1 \
 1.31385e-08 -0.1 \
 1.314642857142857e-08 -0.1 \
 1.314742857142857e-08 0.03333333333333333 \
 1.315535714285714e-08 0.03333333333333333 \
 1.315635714285714e-08 -0.1 \
 1.316428571428571e-08 -0.1 \
 1.316528571428571e-08 0.1 \
 1.317321428571429e-08 0.1 \
 1.317421428571428e-08 0.03333333333333333 \
 1.318214285714286e-08 0.03333333333333333 \
 1.318314285714286e-08 -0.03333333333333333 \
 1.319107142857143e-08 -0.03333333333333333 \
 1.319207142857143e-08 -0.1 \
 1.32e-08 -0.1 \
 1.3201e-08 -0.03333333333333333 \
 1.320892857142857e-08 -0.03333333333333333 \
 1.320992857142857e-08 -0.1 \
 1.321785714285714e-08 -0.1 \
 1.321885714285714e-08 0.1 \
 1.322678571428571e-08 0.1 \
 1.322778571428571e-08 0.1 \
 1.323571428571428e-08 0.1 \
 1.323671428571428e-08 0.1 \
 1.324464285714286e-08 0.1 \
 1.324564285714286e-08 0.1 \
 1.325357142857143e-08 0.1 \
 1.325457142857143e-08 0.03333333333333333 \
 1.32625e-08 0.03333333333333333 \
 1.32635e-08 0.1 \
 1.327142857142857e-08 0.1 \
 1.327242857142857e-08 0.1 \
 1.328035714285714e-08 0.1 \
 1.328135714285714e-08 -0.03333333333333333 \
 1.328928571428571e-08 -0.03333333333333333 \
 1.329028571428571e-08 -0.1 \
 1.329821428571429e-08 -0.1 \
 1.329921428571429e-08 -0.1 \
 1.330714285714286e-08 -0.1 \
 1.330814285714286e-08 -0.1 \
 1.331607142857143e-08 -0.1 \
 1.331707142857143e-08 -0.03333333333333333 \
 1.3325e-08 -0.03333333333333333 \
 1.3326e-08 0.03333333333333333 \
 1.333392857142857e-08 0.03333333333333333 \
 1.333492857142857e-08 -0.03333333333333333 \
 1.334285714285714e-08 -0.03333333333333333 \
 1.334385714285714e-08 -0.03333333333333333 \
 1.335178571428571e-08 -0.03333333333333333 \
 1.335278571428571e-08 0.1 \
 1.336071428571429e-08 0.1 \
 1.336171428571429e-08 0.1 \
 1.336964285714286e-08 0.1 \
 1.337064285714286e-08 -0.1 \
 1.337857142857143e-08 -0.1 \
 1.337957142857143e-08 -0.1 \
 1.33875e-08 -0.1 \
 1.33885e-08 -0.1 \
 1.339642857142857e-08 -0.1 \
 1.339742857142857e-08 0.1 \
 1.340535714285714e-08 0.1 \
 1.340635714285714e-08 -0.1 \
 1.341428571428571e-08 -0.1 \
 1.341528571428571e-08 0.1 \
 1.342321428571429e-08 0.1 \
 1.342421428571429e-08 0.03333333333333333 \
 1.343214285714286e-08 0.03333333333333333 \
 1.343314285714286e-08 0.03333333333333333 \
 1.344107142857143e-08 0.03333333333333333 \
 1.344207142857143e-08 0.1 \
 1.345e-08 0.1 \
 1.3451e-08 0.1 \
 1.345892857142857e-08 0.1 \
 1.345992857142857e-08 -0.03333333333333333 \
 1.346785714285714e-08 -0.03333333333333333 \
 1.346885714285714e-08 0.1 \
 1.347678571428571e-08 0.1 \
 1.347778571428571e-08 0.1 \
 1.348571428571429e-08 0.1 \
 1.348671428571428e-08 0.03333333333333333 \
 1.349464285714286e-08 0.03333333333333333 \
 1.349564285714286e-08 -0.1 \
 1.350357142857143e-08 -0.1 \
 1.350457142857143e-08 0.03333333333333333 \
 1.35125e-08 0.03333333333333333 \
 1.35135e-08 -0.03333333333333333 \
 1.352142857142857e-08 -0.03333333333333333 \
 1.352242857142857e-08 0.03333333333333333 \
 1.353035714285714e-08 0.03333333333333333 \
 1.353135714285714e-08 -0.03333333333333333 \
 1.353928571428571e-08 -0.03333333333333333 \
 1.354028571428571e-08 0.1 \
 1.354821428571429e-08 0.1 \
 1.354921428571428e-08 -0.1 \
 1.355714285714286e-08 -0.1 \
 1.355814285714286e-08 -0.03333333333333333 \
 1.356607142857143e-08 -0.03333333333333333 \
 1.356707142857143e-08 0.03333333333333333 \
 1.3575e-08 0.03333333333333333 \
 1.3576e-08 0.1 \
 1.358392857142857e-08 0.1 \
 1.358492857142857e-08 -0.1 \
 1.359285714285714e-08 -0.1 \
 1.359385714285714e-08 0.1 \
 1.360178571428571e-08 0.1 \
 1.360278571428571e-08 -0.1 \
 1.361071428571428e-08 -0.1 \
 1.361171428571428e-08 -0.03333333333333333 \
 1.361964285714286e-08 -0.03333333333333333 \
 1.362064285714286e-08 0.1 \
 1.362857142857143e-08 0.1 \
 1.362957142857143e-08 0.1 \
 1.36375e-08 0.1 \
 1.36385e-08 -0.1 \
 1.364642857142857e-08 -0.1 \
 1.364742857142857e-08 0.1 \
 1.365535714285714e-08 0.1 \
 1.365635714285714e-08 0.03333333333333333 \
 1.366428571428571e-08 0.03333333333333333 \
 1.366528571428571e-08 0.03333333333333333 \
 1.367321428571429e-08 0.03333333333333333 \
 1.367421428571429e-08 0.03333333333333333 \
 1.368214285714286e-08 0.03333333333333333 \
 1.368314285714286e-08 0.1 \
 1.369107142857143e-08 0.1 \
 1.369207142857143e-08 -0.1 \
 1.37e-08 -0.1 \
 1.3701e-08 0.03333333333333333 \
 1.370892857142857e-08 0.03333333333333333 \
 1.370992857142857e-08 0.03333333333333333 \
 1.371785714285714e-08 0.03333333333333333 \
 1.371885714285714e-08 0.1 \
 1.372678571428571e-08 0.1 \
 1.372778571428571e-08 0.1 \
 1.373571428571429e-08 0.1 \
 1.373671428571429e-08 0.1 \
 1.374464285714286e-08 0.1 \
 1.374564285714286e-08 -0.03333333333333333 \
 1.375357142857143e-08 -0.03333333333333333 \
 1.375457142857143e-08 -0.03333333333333333 \
 1.37625e-08 -0.03333333333333333 \
 1.37635e-08 -0.03333333333333333 \
 1.377142857142857e-08 -0.03333333333333333 \
 1.377242857142857e-08 0.03333333333333333 \
 1.378035714285714e-08 0.03333333333333333 \
 1.378135714285714e-08 0.03333333333333333 \
 1.378928571428571e-08 0.03333333333333333 \
 1.379028571428571e-08 -0.03333333333333333 \
 1.379821428571429e-08 -0.03333333333333333 \
 1.379921428571429e-08 0.03333333333333333 \
 1.380714285714286e-08 0.03333333333333333 \
 1.380814285714286e-08 0.03333333333333333 \
 1.381607142857143e-08 0.03333333333333333 \
 1.381707142857143e-08 -0.03333333333333333 \
 1.3825e-08 -0.03333333333333333 \
 1.3826e-08 0.03333333333333333 \
 1.383392857142857e-08 0.03333333333333333 \
 1.383492857142857e-08 -0.1 \
 1.384285714285714e-08 -0.1 \
 1.384385714285714e-08 0.1 \
 1.385178571428571e-08 0.1 \
 1.385278571428571e-08 -0.03333333333333333 \
 1.386071428571429e-08 -0.03333333333333333 \
 1.386171428571428e-08 0.1 \
 1.386964285714286e-08 0.1 \
 1.387064285714286e-08 0.03333333333333333 \
 1.387857142857143e-08 0.03333333333333333 \
 1.387957142857143e-08 0.1 \
 1.38875e-08 0.1 \
 1.38885e-08 0.1 \
 1.389642857142857e-08 0.1 \
 1.389742857142857e-08 -0.03333333333333333 \
 1.390535714285714e-08 -0.03333333333333333 \
 1.390635714285714e-08 -0.03333333333333333 \
 1.391428571428571e-08 -0.03333333333333333 \
 1.391528571428571e-08 0.03333333333333333 \
 1.392321428571429e-08 0.03333333333333333 \
 1.392421428571428e-08 -0.03333333333333333 \
 1.393214285714286e-08 -0.03333333333333333 \
 1.393314285714286e-08 0.1 \
 1.394107142857143e-08 0.1 \
 1.394207142857143e-08 0.03333333333333333 \
 1.395e-08 0.03333333333333333 \
 1.3951e-08 0.1 \
 1.395892857142857e-08 0.1 \
 1.395992857142857e-08 -0.03333333333333333 \
 1.396785714285714e-08 -0.03333333333333333 \
 1.396885714285714e-08 -0.03333333333333333 \
 1.397678571428571e-08 -0.03333333333333333 \
 1.397778571428571e-08 0.1 \
 1.398571428571428e-08 0.1 \
 1.398671428571428e-08 -0.03333333333333333 \
 1.399464285714286e-08 -0.03333333333333333 \
 1.399564285714286e-08 -0.1 \
 1.400357142857143e-08 -0.1 \
 1.400457142857143e-08 -0.03333333333333333 \
 1.40125e-08 -0.03333333333333333 \
 1.40135e-08 -0.1 \
 1.402142857142857e-08 -0.1 \
 1.402242857142857e-08 -0.03333333333333333 \
 1.403035714285714e-08 -0.03333333333333333 \
 1.403135714285714e-08 -0.1 \
 1.403928571428571e-08 -0.1 \
 1.404028571428571e-08 0.03333333333333333 \
 1.404821428571429e-08 0.03333333333333333 \
 1.404921428571429e-08 0.03333333333333333 \
 1.405714285714286e-08 0.03333333333333333 \
 1.405814285714286e-08 -0.03333333333333333 \
 1.406607142857143e-08 -0.03333333333333333 \
 1.406707142857143e-08 -0.03333333333333333 \
 1.4075e-08 -0.03333333333333333 \
 1.4076e-08 -0.03333333333333333 \
 1.408392857142857e-08 -0.03333333333333333 \
 1.408492857142857e-08 0.03333333333333333 \
 1.409285714285714e-08 0.03333333333333333 \
 1.409385714285714e-08 0.1 \
 1.410178571428571e-08 0.1 \
 1.410278571428571e-08 0.1 \
 1.411071428571429e-08 0.1 \
 1.411171428571429e-08 0.03333333333333333 \
 1.411964285714286e-08 0.03333333333333333 \
 1.412064285714286e-08 -0.03333333333333333 \
 1.412857142857143e-08 -0.03333333333333333 \
 1.412957142857143e-08 -0.1 \
 1.41375e-08 -0.1 \
 1.41385e-08 0.1 \
 1.414642857142857e-08 0.1 \
 1.414742857142857e-08 -0.03333333333333333 \
 1.415535714285714e-08 -0.03333333333333333 \
 1.415635714285714e-08 0.03333333333333333 \
 1.416428571428571e-08 0.03333333333333333 \
 1.416528571428571e-08 0.03333333333333333 \
 1.417321428571429e-08 0.03333333333333333 \
 1.417421428571429e-08 0.1 \
 1.418214285714286e-08 0.1 \
 1.418314285714286e-08 0.03333333333333333 \
 1.419107142857143e-08 0.03333333333333333 \
 1.419207142857143e-08 0.03333333333333333 \
 1.42e-08 0.03333333333333333 \
 1.4201e-08 -0.1 \
 1.420892857142857e-08 -0.1 \
 1.420992857142857e-08 -0.1 \
 1.421785714285714e-08 -0.1 \
 1.421885714285714e-08 0.03333333333333333 \
 1.422678571428571e-08 0.03333333333333333 \
 1.422778571428571e-08 -0.1 \
 1.423571428571429e-08 -0.1 \
 1.423671428571429e-08 0.03333333333333333 \
 1.424464285714286e-08 0.03333333333333333 \
 1.424564285714286e-08 -0.03333333333333333 \
 1.425357142857143e-08 -0.03333333333333333 \
 1.425457142857143e-08 0.1 \
 1.42625e-08 0.1 \
 1.42635e-08 -0.03333333333333333 \
 1.427142857142857e-08 -0.03333333333333333 \
 1.427242857142857e-08 0.1 \
 1.428035714285714e-08 0.1 \
 1.428135714285714e-08 0.03333333333333333 \
 1.428928571428571e-08 0.03333333333333333 \
 1.429028571428571e-08 -0.03333333333333333 \
 1.429821428571429e-08 -0.03333333333333333 \
 1.429921428571428e-08 -0.1 \
 1.430714285714286e-08 -0.1 \
 1.430814285714286e-08 -0.1 \
 1.431607142857143e-08 -0.1 \
 1.431707142857143e-08 -0.1 \
 1.4325e-08 -0.1 \
 1.4326e-08 -0.03333333333333333 \
 1.433392857142857e-08 -0.03333333333333333 \
 1.433492857142857e-08 0.03333333333333333 \
 1.434285714285714e-08 0.03333333333333333 \
 1.434385714285714e-08 -0.03333333333333333 \
 1.435178571428571e-08 -0.03333333333333333 \
 1.435278571428571e-08 0.03333333333333333 \
 1.436071428571429e-08 0.03333333333333333 \
 1.436171428571428e-08 0.03333333333333333 \
 1.436964285714286e-08 0.03333333333333333 \
 1.437064285714286e-08 -0.03333333333333333 \
 1.437857142857143e-08 -0.03333333333333333 \
 1.437957142857143e-08 -0.03333333333333333 \
 1.43875e-08 -0.03333333333333333 \
 1.43885e-08 0.03333333333333333 \
 1.439642857142857e-08 0.03333333333333333 \
 1.439742857142857e-08 0.03333333333333333 \
 1.440535714285714e-08 0.03333333333333333 \
 1.440635714285714e-08 0.03333333333333333 \
 1.441428571428571e-08 0.03333333333333333 \
 1.441528571428571e-08 -0.03333333333333333 \
 1.442321428571429e-08 -0.03333333333333333 \
 1.442421428571429e-08 -0.1 \
 1.443214285714286e-08 -0.1 \
 1.443314285714286e-08 0.03333333333333333 \
 1.444107142857143e-08 0.03333333333333333 \
 1.444207142857143e-08 0.1 \
 1.445e-08 0.1 \
 1.4451e-08 0.03333333333333333 \
 1.445892857142857e-08 0.03333333333333333 \
 1.445992857142857e-08 -0.03333333333333333 \
 1.446785714285714e-08 -0.03333333333333333 \
 1.446885714285714e-08 -0.03333333333333333 \
 1.447678571428571e-08 -0.03333333333333333 \
 1.447778571428571e-08 -0.03333333333333333 \
 1.448571428571429e-08 -0.03333333333333333 \
 1.448671428571429e-08 0.1 \
 1.449464285714286e-08 0.1 \
 1.449564285714286e-08 0.1 \
 1.450357142857143e-08 0.1 \
 1.450457142857143e-08 0.1 \
 1.45125e-08 0.1 \
 1.45135e-08 -0.1 \
 1.452142857142857e-08 -0.1 \
 1.452242857142857e-08 0.03333333333333333 \
 1.453035714285714e-08 0.03333333333333333 \
 1.453135714285714e-08 0.03333333333333333 \
 1.453928571428571e-08 0.03333333333333333 \
 1.454028571428571e-08 0.03333333333333333 \
 1.454821428571429e-08 0.03333333333333333 \
 1.454921428571429e-08 0.1 \
 1.455714285714286e-08 0.1 \
 1.455814285714286e-08 0.1 \
 1.456607142857143e-08 0.1 \
 1.456707142857143e-08 0.03333333333333333 \
 1.4575e-08 0.03333333333333333 \
 1.4576e-08 -0.1 \
 1.458392857142857e-08 -0.1 \
 1.458492857142857e-08 -0.03333333333333333 \
 1.459285714285714e-08 -0.03333333333333333 \
 1.459385714285714e-08 0.03333333333333333 \
 1.460178571428571e-08 0.03333333333333333 \
 1.460278571428571e-08 -0.03333333333333333 \
 1.461071428571429e-08 -0.03333333333333333 \
 1.461171428571429e-08 0.03333333333333333 \
 1.461964285714286e-08 0.03333333333333333 \
 1.462064285714286e-08 -0.03333333333333333 \
 1.462857142857143e-08 -0.03333333333333333 \
 1.462957142857143e-08 0.1 \
 1.46375e-08 0.1 \
 1.46385e-08 0.1 \
 1.464642857142857e-08 0.1 \
 1.464742857142857e-08 0.1 \
 1.465535714285714e-08 0.1 \
 1.465635714285714e-08 0.1 \
 1.466428571428571e-08 0.1 \
 1.466528571428571e-08 -0.03333333333333333 \
 1.467321428571429e-08 -0.03333333333333333 \
 1.467421428571428e-08 0.03333333333333333 \
 1.468214285714286e-08 0.03333333333333333 \
 1.468314285714286e-08 -0.03333333333333333 \
 1.469107142857143e-08 -0.03333333333333333 \
 1.469207142857143e-08 0.03333333333333333 \
 1.47e-08 0.03333333333333333 \
 1.4701e-08 0.1 \
 1.470892857142857e-08 0.1 \
 1.470992857142857e-08 -0.03333333333333333 \
 1.471785714285714e-08 -0.03333333333333333 \
 1.471885714285714e-08 -0.1 \
 1.472678571428571e-08 -0.1 \
 1.472778571428571e-08 -0.1 \
 1.473571428571429e-08 -0.1 \
 1.473671428571428e-08 0.1 \
 1.474464285714286e-08 0.1 \
 1.474564285714286e-08 0.1 \
 1.475357142857143e-08 0.1 \
 1.475457142857143e-08 0.03333333333333333 \
 1.47625e-08 0.03333333333333333 \
 1.47635e-08 0.03333333333333333 \
 1.477142857142857e-08 0.03333333333333333 \
 1.477242857142857e-08 0.03333333333333333 \
 1.478035714285714e-08 0.03333333333333333 \
 1.478135714285714e-08 0.1 \
 1.478928571428571e-08 0.1 \
 1.479028571428571e-08 -0.1 \
 1.479821428571428e-08 -0.1 \
 1.479921428571428e-08 -0.1 \
 1.480714285714286e-08 -0.1 \
 1.480814285714286e-08 -0.03333333333333333 \
 1.481607142857143e-08 -0.03333333333333333 \
 1.481707142857143e-08 -0.03333333333333333 \
 1.4825e-08 -0.03333333333333333 \
 1.4826e-08 -0.1 \
 1.483392857142857e-08 -0.1 \
 1.483492857142857e-08 0.03333333333333333 \
 1.484285714285714e-08 0.03333333333333333 \
 1.484385714285714e-08 0.03333333333333333 \
 1.485178571428571e-08 0.03333333333333333 \
 1.485278571428571e-08 -0.1 \
 1.486071428571429e-08 -0.1 \
 1.486171428571429e-08 -0.1 \
 1.486964285714286e-08 -0.1 \
 1.487064285714286e-08 0.1 \
 1.487857142857143e-08 0.1 \
 1.487957142857143e-08 0.03333333333333333 \
 1.48875e-08 0.03333333333333333 \
 1.48885e-08 -0.03333333333333333 \
 1.489642857142857e-08 -0.03333333333333333 \
 1.489742857142857e-08 -0.03333333333333333 \
 1.490535714285714e-08 -0.03333333333333333 \
 1.490635714285714e-08 0.1 \
 1.491428571428571e-08 0.1 \
 1.491528571428572e-08 0.1 \
 1.492321428571428e-08 0.1 \
 1.492421428571429e-08 -0.1 \
 1.493214285714286e-08 -0.1 \
 1.493314285714286e-08 -0.03333333333333333 \
 1.494107142857143e-08 -0.03333333333333333 \
 1.494207142857143e-08 0.03333333333333333 \
 1.495e-08 0.03333333333333333 \
 1.4951e-08 -0.1 \
 1.495892857142857e-08 -0.1 \
 1.495992857142857e-08 0.1 \
 1.496785714285714e-08 0.1 \
 1.496885714285714e-08 -0.03333333333333333 \
 1.497678571428571e-08 -0.03333333333333333 \
 1.497778571428571e-08 -0.1 \
 1.498571428571429e-08 -0.1 \
 1.498671428571429e-08 -0.03333333333333333 \
 1.499464285714286e-08 -0.03333333333333333 \
 1.499564285714286e-08 0.1 \
 1.500357142857143e-08 0.1 \
 1.500457142857143e-08 0.1 \
 1.50125e-08 0.1 \
 1.50135e-08 0.1 \
 1.502142857142857e-08 0.1 \
 1.502242857142857e-08 0.03333333333333333 \
 1.503035714285714e-08 0.03333333333333333 \
 1.503135714285714e-08 -0.03333333333333333 \
 1.503928571428571e-08 -0.03333333333333333 \
 1.504028571428571e-08 -0.1 \
 1.504821428571428e-08 -0.1 \
 1.504921428571428e-08 -0.03333333333333333 \
 1.505714285714286e-08 -0.03333333333333333 \
 1.505814285714286e-08 -0.1 \
 1.506607142857143e-08 -0.1 \
 1.506707142857143e-08 -0.03333333333333333 \
 1.5075e-08 -0.03333333333333333 \
 1.5076e-08 -0.03333333333333333 \
 1.508392857142857e-08 -0.03333333333333333 \
 1.508492857142857e-08 0.1 \
 1.509285714285714e-08 0.1 \
 1.509385714285714e-08 -0.03333333333333333 \
 1.510178571428571e-08 -0.03333333333333333 \
 1.510278571428571e-08 0.03333333333333333 \
 1.511071428571429e-08 0.03333333333333333 \
 1.511171428571429e-08 -0.1 \
 1.511964285714286e-08 -0.1 \
 1.512064285714286e-08 -0.03333333333333333 \
 1.512857142857143e-08 -0.03333333333333333 \
 1.512957142857143e-08 -0.1 \
 1.51375e-08 -0.1 \
 1.51385e-08 -0.03333333333333333 \
 1.514642857142857e-08 -0.03333333333333333 \
 1.514742857142857e-08 0.1 \
 1.515535714285714e-08 0.1 \
 1.515635714285714e-08 -0.1 \
 1.516428571428571e-08 -0.1 \
 1.516528571428571e-08 -0.03333333333333333 \
 1.517321428571428e-08 -0.03333333333333333 \
 1.517421428571428e-08 -0.1 \
 1.518214285714286e-08 -0.1 \
 1.518314285714286e-08 0.1 \
 1.519107142857143e-08 0.1 \
 1.519207142857143e-08 0.03333333333333333 \
 1.52e-08 0.03333333333333333 \
 1.5201e-08 -0.1 \
 1.520892857142857e-08 -0.1 \
 1.520992857142857e-08 -0.03333333333333333 \
 1.521785714285714e-08 -0.03333333333333333 \
 1.521885714285714e-08 0.03333333333333333 \
 1.522678571428571e-08 0.03333333333333333 \
 1.522778571428571e-08 -0.1 \
 1.523571428571428e-08 -0.1 \
 1.523671428571429e-08 0.1 \
 1.524464285714285e-08 0.1 \
 1.524564285714286e-08 -0.03333333333333333 \
 1.525357142857143e-08 -0.03333333333333333 \
 1.525457142857143e-08 -0.03333333333333333 \
 1.52625e-08 -0.03333333333333333 \
 1.52635e-08 -0.1 \
 1.527142857142857e-08 -0.1 \
 1.527242857142857e-08 0.03333333333333333 \
 1.528035714285714e-08 0.03333333333333333 \
 1.528135714285714e-08 0.1 \
 1.528928571428571e-08 0.1 \
 1.529028571428571e-08 0.03333333333333333 \
 1.529821428571428e-08 0.03333333333333333 \
 1.529921428571428e-08 0.1 \
 1.530714285714286e-08 0.1 \
 1.530814285714286e-08 -0.03333333333333333 \
 1.531607142857143e-08 -0.03333333333333333 \
 1.531707142857143e-08 -0.1 \
 1.5325e-08 -0.1 \
 1.5326e-08 0.1 \
 1.533392857142857e-08 0.1 \
 1.533492857142857e-08 -0.1 \
 1.534285714285714e-08 -0.1 \
 1.534385714285714e-08 0.03333333333333333 \
 1.535178571428571e-08 0.03333333333333333 \
 1.535278571428571e-08 0.03333333333333333 \
 1.536071428571428e-08 0.03333333333333333 \
 1.536171428571429e-08 -0.1 \
 1.536964285714285e-08 -0.1 \
 1.537064285714286e-08 0.03333333333333333 \
 1.537857142857143e-08 0.03333333333333333 \
 1.537957142857143e-08 0.1 \
 1.53875e-08 0.1 \
 1.53885e-08 0.03333333333333333 \
 1.539642857142857e-08 0.03333333333333333 \
 1.539742857142857e-08 -0.1 \
 1.540535714285714e-08 -0.1 \
 1.540635714285714e-08 -0.1 \
 1.541428571428571e-08 -0.1 \
 1.541528571428571e-08 0.1 \
 1.542321428571429e-08 0.1 \
 1.542421428571429e-08 -0.03333333333333333 \
 1.543214285714286e-08 -0.03333333333333333 \
 1.543314285714286e-08 0.03333333333333333 \
 1.544107142857143e-08 0.03333333333333333 \
 1.544207142857143e-08 -0.03333333333333333 \
 1.545e-08 -0.03333333333333333 \
 1.5451e-08 -0.1 \
 1.545892857142857e-08 -0.1 \
 1.545992857142857e-08 0.03333333333333333 \
 1.546785714285714e-08 0.03333333333333333 \
 1.546885714285714e-08 -0.03333333333333333 \
 1.547678571428571e-08 -0.03333333333333333 \
 1.547778571428571e-08 0.03333333333333333 \
 1.548571428571428e-08 0.03333333333333333 \
 1.548671428571428e-08 0.03333333333333333 \
 1.549464285714286e-08 0.03333333333333333 \
 1.549564285714286e-08 0.1 \
 1.550357142857143e-08 0.1 \
 1.550457142857143e-08 -0.1 \
 1.55125e-08 -0.1 \
 1.55135e-08 -0.03333333333333333 \
 1.552142857142857e-08 -0.03333333333333333 \
 1.552242857142857e-08 -0.03333333333333333 \
 1.553035714285714e-08 -0.03333333333333333 \
 1.553135714285714e-08 0.1 \
 1.553928571428571e-08 0.1 \
 1.554028571428571e-08 0.03333333333333333 \
 1.554821428571428e-08 0.03333333333333333 \
 1.554921428571429e-08 0.1 \
 1.555714285714286e-08 0.1 \
 1.555814285714286e-08 -0.03333333333333333 \
 1.556607142857143e-08 -0.03333333333333333 \
 1.556707142857143e-08 -0.1 \
 1.5575e-08 -0.1 \
 1.5576e-08 0.03333333333333333 \
 1.558392857142857e-08 0.03333333333333333 \
 1.558492857142857e-08 0.03333333333333333 \
 1.559285714285714e-08 0.03333333333333333 \
 1.559385714285714e-08 -0.03333333333333333 \
 1.560178571428571e-08 -0.03333333333333333 \
 1.560278571428571e-08 -0.1 \
 1.561071428571428e-08 -0.1 \
 1.561171428571428e-08 0.1 \
 1.561964285714286e-08 0.1 \
 1.562064285714286e-08 0.03333333333333333 \
 1.562857142857143e-08 0.03333333333333333 \
 1.562957142857143e-08 -0.03333333333333333 \
 1.56375e-08 -0.03333333333333333 \
 1.56385e-08 0.03333333333333333 \
 1.564642857142857e-08 0.03333333333333333 \
 1.564742857142857e-08 0.03333333333333333 \
 1.565535714285714e-08 0.03333333333333333 \
 1.565635714285714e-08 0.1 \
 1.566428571428571e-08 0.1 \
 1.566528571428572e-08 0.1 \
 1.567321428571428e-08 0.1 \
 1.567421428571429e-08 -0.03333333333333333 \
 1.568214285714285e-08 -0.03333333333333333 \
 1.568314285714286e-08 -0.03333333333333333 \
 1.569107142857143e-08 -0.03333333333333333 \
 1.569207142857143e-08 -0.1 \
 1.57e-08 -0.1 \
 1.5701e-08 -0.03333333333333333 \
 1.570892857142857e-08 -0.03333333333333333 \
 1.570992857142857e-08 0.03333333333333333 \
 1.571785714285714e-08 0.03333333333333333 \
 1.571885714285714e-08 0.03333333333333333 \
 1.572678571428571e-08 0.03333333333333333 \
 1.572778571428571e-08 -0.1 \
 1.573571428571428e-08 -0.1 \
 1.573671428571428e-08 0.1 \
 1.574464285714286e-08 0.1 \
 1.574564285714286e-08 0.03333333333333333 \
 1.575357142857143e-08 0.03333333333333333 \
 1.575457142857143e-08 0.1 \
 1.57625e-08 0.1 \
 1.57635e-08 -0.1 \
 1.577142857142857e-08 -0.1 \
 1.577242857142857e-08 -0.03333333333333333 \
 1.578035714285714e-08 -0.03333333333333333 \
 1.578135714285714e-08 -0.1 \
 1.578928571428571e-08 -0.1 \
 1.579028571428571e-08 -0.03333333333333333 \
 1.579821428571428e-08 -0.03333333333333333 \
 1.579921428571428e-08 0.03333333333333333 \
 1.580714285714285e-08 0.03333333333333333 \
 1.580814285714286e-08 0.1 \
 1.581607142857143e-08 0.1 \
 1.581707142857143e-08 0.1 \
 1.5825e-08 0.1 \
 1.5826e-08 0.1 \
 1.583392857142857e-08 0.1 \
 1.583492857142857e-08 0.1 \
 1.584285714285714e-08 0.1 \
 1.584385714285714e-08 0.03333333333333333 \
 1.585178571428571e-08 0.03333333333333333 \
 1.585278571428571e-08 0.03333333333333333 \
 1.586071428571429e-08 0.03333333333333333 \
 1.586171428571429e-08 0.1 \
 1.586964285714286e-08 0.1 \
 1.587064285714286e-08 0.03333333333333333 \
 1.587857142857143e-08 0.03333333333333333 \
 1.587957142857143e-08 0.03333333333333333 \
 1.58875e-08 0.03333333333333333 \
 1.58885e-08 0.03333333333333333 \
 1.589642857142857e-08 0.03333333333333333 \
 1.589742857142857e-08 -0.1 \
 1.590535714285714e-08 -0.1 \
 1.590635714285714e-08 -0.1 \
 1.591428571428571e-08 -0.1 \
 1.591528571428571e-08 0.03333333333333333 \
 1.592321428571428e-08 0.03333333333333333 \
 1.592421428571428e-08 0.03333333333333333 \
 1.593214285714286e-08 0.03333333333333333 \
 1.593314285714286e-08 0.1 \
 1.594107142857143e-08 0.1 \
 1.594207142857143e-08 0.03333333333333333 \
 1.595e-08 0.03333333333333333 \
 1.5951e-08 0.03333333333333333 \
 1.595892857142857e-08 0.03333333333333333 \
 1.595992857142857e-08 0.1 \
 1.596785714285714e-08 0.1 \
 1.596885714285714e-08 -0.1 \
 1.597678571428571e-08 -0.1 \
 1.597778571428571e-08 0.03333333333333333 \
 1.598571428571428e-08 0.03333333333333333 \
 1.598671428571429e-08 0.03333333333333333 \
 1.599464285714285e-08 0.03333333333333333 \
 1.599564285714286e-08 -0.1 \
 1.600357142857143e-08 -0.1 \
 1.600457142857143e-08 0.03333333333333333 \
 1.60125e-08 0.03333333333333333 \
 1.60135e-08 -0.03333333333333333 \
 1.602142857142857e-08 -0.03333333333333333 \
 1.602242857142857e-08 0.03333333333333333 \
 1.603035714285714e-08 0.03333333333333333 \
 1.603135714285714e-08 -0.1 \
 1.603928571428571e-08 -0.1 \
 1.604028571428571e-08 0.03333333333333333 \
 1.604821428571428e-08 0.03333333333333333 \
 1.604921428571428e-08 0.1 \
 1.605714285714286e-08 0.1 \
 1.605814285714286e-08 0.1 \
 1.606607142857143e-08 0.1 \
 1.606707142857143e-08 0.03333333333333333 \
 1.6075e-08 0.03333333333333333 \
 1.6076e-08 -0.03333333333333333 \
 1.608392857142857e-08 -0.03333333333333333 \
 1.608492857142857e-08 0.03333333333333333 \
 1.609285714285714e-08 0.03333333333333333 \
 1.609385714285714e-08 0.03333333333333333 \
 1.610178571428571e-08 0.03333333333333333 \
 1.610278571428572e-08 0.03333333333333333 \
 1.611071428571428e-08 0.03333333333333333 \
 1.611171428571429e-08 0.03333333333333333 \
 1.611964285714285e-08 0.03333333333333333 \
 1.612064285714286e-08 0.1 \
 1.612857142857143e-08 0.1 \
 1.612957142857143e-08 0.03333333333333333 \
 1.61375e-08 0.03333333333333333 \
 1.61385e-08 0.1 \
 1.614642857142857e-08 0.1 \
 1.614742857142857e-08 0.1 \
 1.615535714285714e-08 0.1 \
 1.615635714285714e-08 -0.03333333333333333 \
 1.616428571428571e-08 -0.03333333333333333 \
 1.616528571428571e-08 -0.1 \
 1.617321428571429e-08 -0.1 \
 1.617421428571429e-08 0.03333333333333333 \
 1.618214285714286e-08 0.03333333333333333 \
 1.618314285714286e-08 -0.1 \
 1.619107142857143e-08 -0.1 \
 1.619207142857143e-08 -0.03333333333333333 \
 1.62e-08 -0.03333333333333333 \
 1.6201e-08 0.03333333333333333 \
 1.620892857142857e-08 0.03333333333333333 \
 1.620992857142857e-08 -0.03333333333333333 \
 1.621785714285714e-08 -0.03333333333333333 \
 1.621885714285714e-08 -0.03333333333333333 \
 1.622678571428571e-08 -0.03333333333333333 \
 1.622778571428571e-08 0.1 \
 1.623571428571428e-08 0.1 \
 1.623671428571428e-08 -0.1 \
 1.624464285714285e-08 -0.1 \
 1.624564285714285e-08 0.03333333333333333 \
 1.625357142857143e-08 0.03333333333333333 \
 1.625457142857143e-08 0.1 \
 1.62625e-08 0.1 \
 1.62635e-08 0.1 \
 1.627142857142857e-08 0.1 \
 1.627242857142857e-08 0.03333333333333333 \
 1.628035714285714e-08 0.03333333333333333 \
 1.628135714285714e-08 -0.1 \
 1.628928571428571e-08 -0.1 \
 1.629028571428571e-08 0.1 \
 1.629821428571429e-08 0.1 \
 1.629921428571429e-08 0.03333333333333333 \
 1.630714285714286e-08 0.03333333333333333 \
 1.630814285714286e-08 0.03333333333333333 \
 1.631607142857143e-08 0.03333333333333333 \
 1.631707142857143e-08 -0.1 \
 1.6325e-08 -0.1 \
 1.6326e-08 -0.1 \
 1.633392857142857e-08 -0.1 \
 1.633492857142857e-08 -0.03333333333333333 \
 1.634285714285714e-08 -0.03333333333333333 \
 1.634385714285714e-08 0.1 \
 1.635178571428571e-08 0.1 \
 1.635278571428571e-08 -0.1 \
 1.636071428571428e-08 -0.1 \
 1.636171428571428e-08 0.03333333333333333 \
 1.636964285714286e-08 0.03333333333333333 \
 1.637064285714286e-08 -0.1 \
 1.637857142857143e-08 -0.1 \
 1.637957142857143e-08 0.1 \
 1.63875e-08 0.1 \
 1.63885e-08 -0.1 \
 1.639642857142857e-08 -0.1 \
 1.639742857142857e-08 0.03333333333333333 \
 1.640535714285714e-08 0.03333333333333333 \
 1.640635714285714e-08 0.03333333333333333 \
 1.641428571428571e-08 0.03333333333333333 \
 1.641528571428571e-08 -0.03333333333333333 \
 1.642321428571428e-08 -0.03333333333333333 \
 1.642421428571429e-08 -0.1 \
 1.643214285714285e-08 -0.1 \
 1.643314285714286e-08 0.1 \
 1.644107142857143e-08 0.1 \
 1.644207142857143e-08 0.1 \
 1.645e-08 0.1 \
 1.6451e-08 0.1 \
 1.645892857142857e-08 0.1 \
 1.645992857142857e-08 0.03333333333333333 \
 1.646785714285714e-08 0.03333333333333333 \
 1.646885714285714e-08 -0.03333333333333333 \
 1.647678571428571e-08 -0.03333333333333333 \
 1.647778571428571e-08 0.1 \
 1.648571428571428e-08 0.1 \
 1.648671428571428e-08 0.1 \
 1.649464285714286e-08 0.1 \
 1.649564285714286e-08 0.03333333333333333 \
 1.650357142857143e-08 0.03333333333333333 \
 1.650457142857143e-08 0.03333333333333333 \
 1.65125e-08 0.03333333333333333 \
 1.65135e-08 0.1 \
 1.652142857142857e-08 0.1 \
 1.652242857142857e-08 -0.1 \
 1.653035714285714e-08 -0.1 \
 1.653135714285714e-08 0.03333333333333333 \
 1.653928571428571e-08 0.03333333333333333 \
 1.654028571428571e-08 0.1 \
 1.654821428571428e-08 0.1 \
 1.654921428571429e-08 -0.03333333333333333 \
 1.655714285714285e-08 -0.03333333333333333 \
 1.655814285714286e-08 -0.03333333333333333 \
 1.656607142857143e-08 -0.03333333333333333 \
 1.656707142857143e-08 0.1 \
 1.6575e-08 0.1 \
 1.6576e-08 0.03333333333333333 \
 1.658392857142857e-08 0.03333333333333333 \
 1.658492857142857e-08 -0.1 \
 1.659285714285714e-08 -0.1 \
 1.659385714285714e-08 -0.1 \
 1.660178571428571e-08 -0.1 \
 1.660278571428571e-08 -0.1 \
 1.661071428571429e-08 -0.1 \
 1.661171428571429e-08 0.1 \
 1.661964285714286e-08 0.1 \
 1.662064285714286e-08 -0.03333333333333333 \
 1.662857142857143e-08 -0.03333333333333333 \
 1.662957142857143e-08 -0.1 \
 1.66375e-08 -0.1 \
 1.66385e-08 -0.1 \
 1.664642857142857e-08 -0.1 \
 1.664742857142857e-08 0.03333333333333333 \
 1.665535714285714e-08 0.03333333333333333 \
 1.665635714285714e-08 0.1 \
 1.666428571428571e-08 0.1 \
 1.666528571428571e-08 -0.1 \
 1.667321428571428e-08 -0.1 \
 1.667421428571428e-08 0.1 \
 1.668214285714286e-08 0.1 \
 1.668314285714286e-08 -0.1 \
 1.669107142857143e-08 -0.1 \
 1.669207142857143e-08 -0.03333333333333333 \
 1.67e-08 -0.03333333333333333 \
 1.6701e-08 0.03333333333333333 \
 1.670892857142857e-08 0.03333333333333333 \
 1.670992857142857e-08 -0.03333333333333333 \
 1.671785714285714e-08 -0.03333333333333333 \
 1.671885714285714e-08 0.03333333333333333 \
 1.672678571428571e-08 0.03333333333333333 \
 1.672778571428571e-08 0.1 \
 1.673571428571428e-08 0.1 \
 1.673671428571429e-08 -0.03333333333333333 \
 1.674464285714285e-08 -0.03333333333333333 \
 1.674564285714286e-08 0.03333333333333333 \
 1.675357142857143e-08 0.03333333333333333 \
 1.675457142857143e-08 0.1 \
 1.67625e-08 0.1 \
 1.67635e-08 -0.1 \
 1.677142857142857e-08 -0.1 \
 1.677242857142857e-08 -0.03333333333333333 \
 1.678035714285714e-08 -0.03333333333333333 \
 1.678135714285714e-08 0.03333333333333333 \
 1.678928571428571e-08 0.03333333333333333 \
 1.679028571428571e-08 0.03333333333333333 \
 1.679821428571428e-08 0.03333333333333333 \
 1.679921428571428e-08 0.03333333333333333 \
 1.680714285714286e-08 0.03333333333333333 \
 1.680814285714286e-08 0.1 \
 1.681607142857143e-08 0.1 \
 1.681707142857143e-08 -0.03333333333333333 \
 1.6825e-08 -0.03333333333333333 \
 1.6826e-08 0.03333333333333333 \
 1.683392857142857e-08 0.03333333333333333 \
 1.683492857142857e-08 -0.03333333333333333 \
 1.684285714285714e-08 -0.03333333333333333 \
 1.684385714285714e-08 0.03333333333333333 \
 1.685178571428571e-08 0.03333333333333333 \
 1.685278571428572e-08 -0.1 \
 1.686071428571428e-08 -0.1 \
 1.686171428571429e-08 0.1 \
 1.686964285714285e-08 0.1 \
 1.687064285714286e-08 0.03333333333333333 \
 1.687857142857143e-08 0.03333333333333333 \
 1.687957142857143e-08 0.1 \
 1.68875e-08 0.1 \
 1.68885e-08 0.03333333333333333 \
 1.689642857142857e-08 0.03333333333333333 \
 1.689742857142857e-08 0.1 \
 1.690535714285714e-08 0.1 \
 1.690635714285714e-08 -0.03333333333333333 \
 1.691428571428571e-08 -0.03333333333333333 \
 1.691528571428571e-08 0.03333333333333333 \
 1.692321428571428e-08 0.03333333333333333 \
 1.692421428571428e-08 -0.1 \
 1.693214285714286e-08 -0.1 \
 1.693314285714286e-08 -0.1 \
 1.694107142857143e-08 -0.1 \
 1.694207142857143e-08 -0.1 \
 1.695e-08 -0.1 \
 1.6951e-08 0.03333333333333333 \
 1.695892857142857e-08 0.03333333333333333 \
 1.695992857142857e-08 -0.1 \
 1.696785714285714e-08 -0.1 \
 1.696885714285714e-08 0.1 \
 1.697678571428571e-08 0.1 \
 1.697778571428571e-08 0.1 \
 1.698571428571428e-08 0.1 \
 1.698671428571428e-08 0.03333333333333333 \
 1.699464285714285e-08 0.03333333333333333 \
 1.699564285714286e-08 0.1 \
 1.700357142857143e-08 0.1 \
 1.700457142857143e-08 0.1 \
 1.70125e-08 0.1 \
 1.70135e-08 -0.1 \
 1.702142857142857e-08 -0.1 \
 1.702242857142857e-08 -0.03333333333333333 \
 1.703035714285714e-08 -0.03333333333333333 \
 1.703135714285714e-08 0.03333333333333333 \
 1.703928571428571e-08 0.03333333333333333 \
 1.704028571428571e-08 0.03333333333333333 \
 1.704821428571429e-08 0.03333333333333333 \
 1.704921428571429e-08 0.03333333333333333 \
 1.705714285714286e-08 0.03333333333333333 \
 1.705814285714286e-08 -0.03333333333333333 \
 1.706607142857143e-08 -0.03333333333333333 \
 1.706707142857143e-08 0.03333333333333333 \
 1.7075e-08 0.03333333333333333 \
 1.7076e-08 0.1 \
 1.708392857142857e-08 0.1 \
 1.708492857142857e-08 -0.1 \
 1.709285714285714e-08 -0.1 \
 1.709385714285714e-08 -0.1 \
 1.710178571428571e-08 -0.1 \
 1.710278571428571e-08 -0.03333333333333333 \
 1.711071428571428e-08 -0.03333333333333333 \
 1.711171428571428e-08 -0.03333333333333333 \
 1.711964285714286e-08 -0.03333333333333333 \
 1.712064285714286e-08 -0.1 \
 1.712857142857143e-08 -0.1 \
 1.712957142857143e-08 0.03333333333333333 \
 1.71375e-08 0.03333333333333333 \
 1.71385e-08 0.03333333333333333 \
 1.714642857142857e-08 0.03333333333333333 \
 1.714742857142857e-08 -0.03333333333333333 \
 1.715535714285714e-08 -0.03333333333333333 \
 1.715635714285714e-08 -0.03333333333333333 \
 1.716428571428571e-08 -0.03333333333333333 \
 1.716528571428571e-08 0.1 \
 1.717321428571428e-08 0.1 \
 1.717421428571429e-08 0.1 \
 1.718214285714285e-08 0.1 \
 1.718314285714286e-08 -0.03333333333333333 \
 1.719107142857143e-08 -0.03333333333333333 \
 1.719207142857143e-08 0.1 \
 1.72e-08 0.1 \
 1.7201e-08 -0.1 \
 1.720892857142857e-08 -0.1 \
 1.720992857142857e-08 -0.03333333333333333 \
 1.721785714285714e-08 -0.03333333333333333 \
 1.721885714285714e-08 0.03333333333333333 \
 1.722678571428571e-08 0.03333333333333333 \
 1.722778571428571e-08 0.03333333333333333 \
 1.723571428571428e-08 0.03333333333333333 \
 1.723671428571428e-08 0.1 \
 1.724464285714286e-08 0.1 \
 1.724564285714286e-08 0.1 \
 1.725357142857143e-08 0.1 \
 1.725457142857143e-08 0.1 \
 1.72625e-08 0.1 \
 1.72635e-08 -0.1 \
 1.727142857142857e-08 -0.1 \
 1.727242857142857e-08 -0.1 \
 1.728035714285714e-08 -0.1 \
 1.728135714285714e-08 0.03333333333333333 \
 1.728928571428571e-08 0.03333333333333333 \
 1.729028571428571e-08 0.1 \
 1.729821428571428e-08 0.1 \
 1.729921428571429e-08 -0.1 \
 1.730714285714285e-08 -0.1 \
 1.730814285714286e-08 0.1 \
 1.731607142857143e-08 0.1 \
 1.731707142857143e-08 -0.03333333333333333 \
 1.7325e-08 -0.03333333333333333 \
 1.7326e-08 -0.03333333333333333 \
 1.733392857142857e-08 -0.03333333333333333 \
 1.733492857142857e-08 -0.03333333333333333 \
 1.734285714285714e-08 -0.03333333333333333 \
 1.734385714285714e-08 -0.1 \
 1.735178571428571e-08 -0.1 \
 1.735278571428571e-08 -0.1 \
 1.736071428571429e-08 -0.1 \
 1.736171428571429e-08 -0.1 \
 1.736964285714286e-08 -0.1 \
 1.737064285714286e-08 0.1 \
 1.737857142857143e-08 0.1 \
 1.737957142857143e-08 0.1 \
 1.73875e-08 0.1 \
 1.73885e-08 0.1 \
 1.739642857142857e-08 0.1 \
 1.739742857142857e-08 -0.1 \
 1.740535714285714e-08 -0.1 \
 1.740635714285714e-08 -0.03333333333333333 \
 1.741428571428571e-08 -0.03333333333333333 \
 1.741528571428571e-08 -0.03333333333333333 \
 1.742321428571428e-08 -0.03333333333333333 \
 1.742421428571428e-08 0.03333333333333333 \
 1.743214285714285e-08 0.03333333333333333 \
 1.743314285714285e-08 0.03333333333333333 \
 1.744107142857143e-08 0.03333333333333333 \
 1.744207142857143e-08 0.1 \
 1.745e-08 0.1 \
 1.7451e-08 0.03333333333333333 \
 1.745892857142857e-08 0.03333333333333333 \
 1.745992857142857e-08 -0.03333333333333333 \
 1.746785714285714e-08 -0.03333333333333333 \
 1.746885714285714e-08 0.1 \
 1.747678571428571e-08 0.1 \
 1.747778571428571e-08 0.1 \
 1.748571428571428e-08 0.1 \
 1.748671428571429e-08 -0.03333333333333333 \
 1.749464285714286e-08 -0.03333333333333333 \
 1.749564285714286e-08 -0.03333333333333333 \
 1.750357142857143e-08 -0.03333333333333333 \
 1.750457142857143e-08 -0.1 \
 1.75125e-08 -0.1 \
 1.75135e-08 -0.1 \
 1.752142857142857e-08 -0.1 \
 1.752242857142857e-08 -0.1 \
 1.753035714285714e-08 -0.1 \
 1.753135714285714e-08 -0.03333333333333333 \
 1.753928571428571e-08 -0.03333333333333333 \
 1.754028571428571e-08 -0.03333333333333333 \
 1.754821428571428e-08 -0.03333333333333333 \
 1.754921428571428e-08 -0.1 \
 1.755714285714286e-08 -0.1 \
 1.755814285714286e-08 0.03333333333333333 \
 1.756607142857143e-08 0.03333333333333333 \
 1.756707142857143e-08 0.1 \
 1.7575e-08 0.1 \
 1.7576e-08 0.1 \
 1.758392857142857e-08 0.1 \
 1.758492857142857e-08 -0.03333333333333333 \
 1.759285714285714e-08 -0.03333333333333333 \
 1.759385714285714e-08 -0.03333333333333333 \
 1.760178571428571e-08 -0.03333333333333333 \
 1.760278571428572e-08 0.1 \
 1.761071428571428e-08 0.1 \
 1.761171428571429e-08 -0.1 \
 1.761964285714285e-08 -0.1 \
 1.762064285714286e-08 0.03333333333333333 \
 1.762857142857143e-08 0.03333333333333333 \
 1.762957142857143e-08 0.1 \
 1.76375e-08 0.1 \
 1.76385e-08 -0.03333333333333333 \
 1.764642857142857e-08 -0.03333333333333333 \
 1.764742857142857e-08 -0.03333333333333333 \
 1.765535714285714e-08 -0.03333333333333333 \
 1.765635714285714e-08 -0.03333333333333333 \
 1.766428571428571e-08 -0.03333333333333333 \
 1.766528571428571e-08 0.03333333333333333 \
 1.767321428571428e-08 0.03333333333333333 \
 1.767421428571428e-08 0.1 \
 1.768214285714286e-08 0.1 \
 1.768314285714286e-08 -0.03333333333333333 \
 1.769107142857143e-08 -0.03333333333333333 \
 1.769207142857143e-08 0.1 \
 1.77e-08 0.1 \
 1.7701e-08 0.03333333333333333 \
 1.770892857142857e-08 0.03333333333333333 \
 1.770992857142857e-08 -0.1 \
 1.771785714285714e-08 -0.1 \
 1.771885714285714e-08 0.03333333333333333 \
 1.772678571428571e-08 0.03333333333333333 \
 1.772778571428571e-08 0.03333333333333333 \
 1.773571428571428e-08 0.03333333333333333 \
 1.773671428571428e-08 -0.03333333333333333 \
 1.774464285714285e-08 -0.03333333333333333 \
 1.774564285714286e-08 0.03333333333333333 \
 1.775357142857143e-08 0.03333333333333333 \
 1.775457142857143e-08 0.1 \
 1.77625e-08 0.1 \
 1.77635e-08 0.03333333333333333 \
 1.777142857142857e-08 0.03333333333333333 \
 1.777242857142857e-08 0.1 \
 1.778035714285714e-08 0.1 \
 1.778135714285714e-08 -0.03333333333333333 \
 1.778928571428571e-08 -0.03333333333333333 \
 1.779028571428571e-08 -0.03333333333333333 \
 1.779821428571429e-08 -0.03333333333333333 \
 1.779921428571429e-08 -0.03333333333333333 \
 1.780714285714286e-08 -0.03333333333333333 \
 1.780814285714286e-08 -0.1 \
 1.781607142857143e-08 -0.1 \
 1.781707142857143e-08 0.03333333333333333 \
 1.7825e-08 0.03333333333333333 \
 1.7826e-08 0.03333333333333333 \
 1.783392857142857e-08 0.03333333333333333 \
 1.783492857142857e-08 0.03333333333333333 \
 1.784285714285714e-08 0.03333333333333333 \
 1.784385714285714e-08 0.1 \
 1.785178571428571e-08 0.1 \
 1.785278571428571e-08 0.1 \
 1.786071428571428e-08 0.1 \
 1.786171428571428e-08 -0.1 \
 1.786964285714286e-08 -0.1 \
 1.787064285714286e-08 -0.1 \
 1.787857142857143e-08 -0.1 \
 1.787957142857143e-08 -0.1 \
 1.78875e-08 -0.1 \
 1.78885e-08 0.1 \
 1.789642857142857e-08 0.1 \
 1.789742857142857e-08 -0.03333333333333333 \
 1.790535714285714e-08 -0.03333333333333333 \
 1.790635714285714e-08 -0.03333333333333333 \
 1.791428571428571e-08 -0.03333333333333333 \
 1.791528571428571e-08 0.1 \
 1.792321428571428e-08 0.1 \
 1.792421428571429e-08 -0.1 \
 1.793214285714285e-08 -0.1 \
 1.793314285714286e-08 -0.03333333333333333 \
 1.794107142857143e-08 -0.03333333333333333 \
 1.794207142857143e-08 0.1 \
 1.795e-08 0.1 \
 1.7951e-08 -0.1 \
 1.795892857142857e-08 -0.1 \
 1.795992857142857e-08 0.03333333333333333 \
 1.796785714285714e-08 0.03333333333333333 \
 1.796885714285714e-08 0.1 \
 1.797678571428571e-08 0.1 \
 1.797778571428571e-08 -0.03333333333333333 \
 1.798571428571428e-08 -0.03333333333333333 \
 1.798671428571428e-08 0.1 \
 1.799464285714286e-08 0.1 \
 1.799564285714286e-08 -0.1 \
 1.800357142857143e-08 -0.1 \
 1.800457142857143e-08 -0.03333333333333333 \
 1.80125e-08 -0.03333333333333333 \
 1.80135e-08 0.1 \
 1.802142857142857e-08 0.1 \
 1.802242857142857e-08 -0.1 \
 1.803035714285714e-08 -0.1 \
 1.803135714285714e-08 -0.1 \
 1.803928571428571e-08 -0.1 \
 1.804028571428572e-08 -0.1 \
 1.804821428571428e-08 -0.1 \
 1.804921428571429e-08 0.03333333333333333 \
 1.805714285714285e-08 0.03333333333333333 \
 1.805814285714286e-08 -0.03333333333333333 \
 1.806607142857143e-08 -0.03333333333333333 \
 1.806707142857143e-08 0.03333333333333333 \
 1.8075e-08 0.03333333333333333 \
 1.8076e-08 0.1 \
 1.808392857142857e-08 0.1 \
 1.808492857142857e-08 -0.1 \
 1.809285714285714e-08 -0.1 \
 1.809385714285714e-08 -0.1 \
 1.810178571428571e-08 -0.1 \
 1.810278571428571e-08 -0.1 \
 1.811071428571429e-08 -0.1 \
 1.811171428571429e-08 -0.1 \
 1.811964285714286e-08 -0.1 \
 1.812064285714286e-08 -0.1 \
 1.812857142857143e-08 -0.1 \
 1.812957142857143e-08 -0.1 \
 1.81375e-08 -0.1 \
 1.81385e-08 -0.1 \
 1.814642857142857e-08 -0.1 \
 1.814742857142857e-08 0.1 \
 1.815535714285714e-08 0.1 \
 1.815635714285714e-08 -0.03333333333333333 \
 1.816428571428571e-08 -0.03333333333333333 \
 1.816528571428571e-08 0.1 \
 1.817321428571428e-08 0.1 \
 1.817421428571428e-08 -0.03333333333333333 \
 1.818214285714285e-08 -0.03333333333333333 \
 1.818314285714285e-08 -0.03333333333333333 \
 1.819107142857143e-08 -0.03333333333333333 \
 1.819207142857143e-08 -0.1 \
 1.82e-08 -0.1 \
 1.8201e-08 -0.1 \
 1.820892857142857e-08 -0.1 \
 1.820992857142857e-08 0.1 \
 1.821785714285714e-08 0.1 \
 1.821885714285714e-08 0.03333333333333333 \
 1.822678571428571e-08 0.03333333333333333 \
 1.822778571428571e-08 0.1 \
 1.823571428571428e-08 0.1 \
 1.823671428571429e-08 -0.1 \
 1.824464285714286e-08 -0.1 \
 1.824564285714286e-08 0.1 \
 1.825357142857143e-08 0.1 \
 1.825457142857143e-08 0.03333333333333333 \
 1.82625e-08 0.03333333333333333 \
 1.82635e-08 0.1 \
 1.827142857142857e-08 0.1 \
 1.827242857142857e-08 0.03333333333333333 \
 1.828035714285714e-08 0.03333333333333333 \
 1.828135714285714e-08 0.03333333333333333 \
 1.828928571428571e-08 0.03333333333333333 \
 1.829028571428571e-08 -0.03333333333333333 \
 1.829821428571428e-08 -0.03333333333333333 \
 1.829921428571428e-08 0.03333333333333333 \
 1.830714285714286e-08 0.03333333333333333 \
 1.830814285714286e-08 -0.1 \
 1.831607142857143e-08 -0.1 \
 1.831707142857143e-08 -0.1 \
 1.8325e-08 -0.1 \
 1.8326e-08 0.1 \
 1.833392857142857e-08 0.1 \
 1.833492857142857e-08 0.03333333333333333 \
 1.834285714285714e-08 0.03333333333333333 \
 1.834385714285714e-08 0.1 \
 1.835178571428571e-08 0.1 \
 1.835278571428571e-08 -0.03333333333333333 \
 1.836071428571428e-08 -0.03333333333333333 \
 1.836171428571429e-08 -0.03333333333333333 \
 1.836964285714285e-08 -0.03333333333333333 \
 1.837064285714286e-08 0.1 \
 1.837857142857143e-08 0.1 \
 1.837957142857143e-08 -0.1 \
 1.83875e-08 -0.1 \
 1.83885e-08 -0.1 \
 1.839642857142857e-08 -0.1 \
 1.839742857142857e-08 -0.1 \
 1.840535714285714e-08 -0.1 \
 1.840635714285714e-08 0.03333333333333333 \
 1.841428571428571e-08 0.03333333333333333 \
 1.841528571428571e-08 -0.1 \
 1.842321428571428e-08 -0.1 \
 1.842421428571428e-08 -0.03333333333333333 \
 1.843214285714286e-08 -0.03333333333333333 \
 1.843314285714286e-08 0.1 \
 1.844107142857143e-08 0.1 \
 1.844207142857143e-08 -0.1 \
 1.845e-08 -0.1 \
 1.8451e-08 -0.1 \
 1.845892857142857e-08 -0.1 \
 1.845992857142857e-08 -0.03333333333333333 \
 1.846785714285714e-08 -0.03333333333333333 \
 1.846885714285714e-08 -0.03333333333333333 \
 1.847678571428571e-08 -0.03333333333333333 \
 1.847778571428571e-08 -0.1 \
 1.848571428571428e-08 -0.1 \
 1.848671428571429e-08 0.03333333333333333 \
 1.849464285714285e-08 0.03333333333333333 \
 1.849564285714286e-08 -0.1 \
 1.850357142857143e-08 -0.1 \
 1.850457142857143e-08 -0.1 \
 1.85125e-08 -0.1 \
 1.85135e-08 -0.1 \
 1.852142857142857e-08 -0.1 \
 1.852242857142857e-08 -0.03333333333333333 \
 1.853035714285714e-08 -0.03333333333333333 \
 1.853135714285714e-08 -0.1 \
 1.853928571428571e-08 -0.1 \
 1.854028571428571e-08 0.1 \
 1.854821428571429e-08 0.1 \
 1.854921428571429e-08 0.03333333333333333 \
 1.855714285714286e-08 0.03333333333333333 \
 1.855814285714286e-08 -0.03333333333333333 \
 1.856607142857143e-08 -0.03333333333333333 \
 1.856707142857143e-08 -0.1 \
 1.8575e-08 -0.1 \
 1.8576e-08 -0.1 \
 1.858392857142857e-08 -0.1 \
 1.858492857142857e-08 0.1 \
 1.859285714285714e-08 0.1 \
 1.859385714285714e-08 -0.1 \
 1.860178571428571e-08 -0.1 \
 1.860278571428571e-08 -0.1 \
 1.861071428571428e-08 -0.1 \
 1.861171428571428e-08 -0.1 \
 1.861964285714286e-08 -0.1 \
 1.862064285714286e-08 0.03333333333333333 \
 1.862857142857143e-08 0.03333333333333333 \
 1.862957142857143e-08 -0.1 \
 1.86375e-08 -0.1 \
 1.86385e-08 0.03333333333333333 \
 1.864642857142857e-08 0.03333333333333333 \
 1.864742857142857e-08 -0.03333333333333333 \
 1.865535714285714e-08 -0.03333333333333333 \
 1.865635714285714e-08 -0.1 \
 1.866428571428571e-08 -0.1 \
 1.866528571428571e-08 -0.03333333333333333 \
 1.867321428571428e-08 -0.03333333333333333 \
 1.867421428571429e-08 -0.03333333333333333 \
 1.868214285714285e-08 -0.03333333333333333 \
 1.868314285714286e-08 -0.1 \
 1.869107142857143e-08 -0.1 \
 1.869207142857143e-08 0.1 \
 1.87e-08 0.1 \
 1.8701e-08 0.1 \
 1.870892857142857e-08 0.1 \
 1.870992857142857e-08 0.1 \
 1.871785714285714e-08 0.1 \
 1.871885714285714e-08 -0.1 \
 1.872678571428571e-08 -0.1 \
 1.872778571428571e-08 -0.1 \
 1.873571428571428e-08 -0.1 \
 1.873671428571428e-08 -0.03333333333333333 \
 1.874464285714286e-08 -0.03333333333333333 \
 1.874564285714286e-08 -0.1 \
 1.875357142857143e-08 -0.1 \
 1.875457142857143e-08 -0.1 \
 1.87625e-08 -0.1 \
 1.87635e-08 -0.03333333333333333 \
 1.877142857142857e-08 -0.03333333333333333 \
 1.877242857142857e-08 -0.1 \
 1.878035714285714e-08 -0.1 \
 1.878135714285714e-08 0.03333333333333333 \
 1.878928571428571e-08 0.03333333333333333 \
 1.879028571428572e-08 0.03333333333333333 \
 1.879821428571428e-08 0.03333333333333333 \
 1.879921428571429e-08 -0.1 \
 1.880714285714285e-08 -0.1 \
 1.880814285714286e-08 0.03333333333333333 \
 1.881607142857143e-08 0.03333333333333333 \
 1.881707142857143e-08 -0.03333333333333333 \
 1.8825e-08 -0.03333333333333333 \
 1.8826e-08 -0.1 \
 1.883392857142857e-08 -0.1 \
 1.883492857142857e-08 -0.1 \
 1.884285714285714e-08 -0.1 \
 1.884385714285714e-08 -0.1 \
 1.885178571428571e-08 -0.1 \
 1.885278571428571e-08 0.03333333333333333 \
 1.886071428571428e-08 0.03333333333333333 \
 1.886171428571428e-08 -0.1 \
 1.886964285714286e-08 -0.1 \
 1.887064285714286e-08 -0.03333333333333333 \
 1.887857142857143e-08 -0.03333333333333333 \
 1.887957142857143e-08 -0.1 \
 1.88875e-08 -0.1 \
 1.88885e-08 0.1 \
 1.889642857142857e-08 0.1 \
 1.889742857142857e-08 -0.03333333333333333 \
 1.890535714285714e-08 -0.03333333333333333 \
 1.890635714285714e-08 0.1 \
 1.891428571428571e-08 0.1 \
 1.891528571428571e-08 0.03333333333333333 \
 1.892321428571428e-08 0.03333333333333333 \
 1.892421428571428e-08 0.1 \
 1.893214285714285e-08 0.1 \
 1.893314285714286e-08 0.03333333333333333 \
 1.894107142857143e-08 0.03333333333333333 \
 1.894207142857143e-08 0.03333333333333333 \
 1.895e-08 0.03333333333333333 \
 1.8951e-08 -0.03333333333333333 \
 1.895892857142857e-08 -0.03333333333333333 \
 1.895992857142857e-08 -0.1 \
 1.896785714285714e-08 -0.1 \
 1.896885714285714e-08 0.03333333333333333 \
 1.897678571428571e-08 0.03333333333333333 \
 1.897778571428571e-08 -0.03333333333333333 \
 1.898571428571429e-08 -0.03333333333333333 \
 1.898671428571429e-08 -0.03333333333333333 \
 1.899464285714286e-08 -0.03333333333333333 \
 1.899564285714286e-08 0.03333333333333333 \
 1.900357142857143e-08 0.03333333333333333 \
 1.900457142857143e-08 0.1 \
 1.90125e-08 0.1 \
 1.90135e-08 0.03333333333333333 \
 1.902142857142857e-08 0.03333333333333333 \
 1.902242857142857e-08 0.1 \
 1.903035714285714e-08 0.1 \
 1.903135714285714e-08 0.1 \
 1.903928571428571e-08 0.1 \
 1.904028571428571e-08 -0.03333333333333333 \
 1.904821428571428e-08 -0.03333333333333333 \
 1.904921428571428e-08 0.1 \
 1.905714285714286e-08 0.1 \
 1.905814285714286e-08 -0.03333333333333333 \
 1.906607142857143e-08 -0.03333333333333333 \
 1.906707142857143e-08 0.03333333333333333 \
 1.9075e-08 0.03333333333333333 \
 1.9076e-08 -0.1 \
 1.908392857142857e-08 -0.1 \
 1.908492857142857e-08 -0.1 \
 1.909285714285714e-08 -0.1 \
 1.909385714285714e-08 -0.03333333333333333 \
 1.910178571428571e-08 -0.03333333333333333 \
 1.910278571428571e-08 -0.1 \
 1.911071428571428e-08 -0.1 \
 1.911171428571429e-08 -0.03333333333333333 \
 1.911964285714285e-08 -0.03333333333333333 \
 1.912064285714286e-08 -0.1 \
 1.912857142857143e-08 -0.1 \
 1.912957142857143e-08 -0.03333333333333333 \
 1.91375e-08 -0.03333333333333333 \
 1.91385e-08 -0.1 \
 1.914642857142857e-08 -0.1 \
 1.914742857142857e-08 0.03333333333333333 \
 1.915535714285714e-08 0.03333333333333333 \
 1.915635714285714e-08 -0.03333333333333333 \
 1.916428571428571e-08 -0.03333333333333333 \
 1.916528571428571e-08 -0.1 \
 1.917321428571428e-08 -0.1 \
 1.917421428571428e-08 -0.1 \
 1.918214285714286e-08 -0.1 \
 1.918314285714286e-08 -0.1 \
 1.919107142857143e-08 -0.1 \
 1.919207142857143e-08 0.1 \
 1.92e-08 0.1 \
 1.9201e-08 -0.1 \
 1.920892857142857e-08 -0.1 \
 1.920992857142857e-08 0.1 \
 1.921785714285714e-08 0.1 \
 1.921885714285714e-08 -0.03333333333333333 \
 1.922678571428571e-08 -0.03333333333333333 \
 1.922778571428571e-08 -0.1 \
 1.923571428571428e-08 -0.1 \
 1.923671428571429e-08 -0.1 \
 1.924464285714285e-08 -0.1 \
 1.924564285714286e-08 0.1 \
 1.925357142857143e-08 0.1 \
 1.925457142857143e-08 0.1 \
 1.92625e-08 0.1 \
 1.92635e-08 -0.03333333333333333 \
 1.927142857142857e-08 -0.03333333333333333 \
 1.927242857142857e-08 -0.03333333333333333 \
 1.928035714285714e-08 -0.03333333333333333 \
 1.928135714285714e-08 -0.1 \
 1.928928571428571e-08 -0.1 \
 1.929028571428571e-08 0.03333333333333333 \
 1.929821428571429e-08 0.03333333333333333 \
 1.929921428571429e-08 -0.1 \
 1.930714285714286e-08 -0.1 \
 1.930814285714286e-08 0.03333333333333333 \
 1.931607142857143e-08 0.03333333333333333 \
 1.931707142857143e-08 -0.1 \
 1.9325e-08 -0.1 \
 1.9326e-08 0.03333333333333333 \
 1.933392857142857e-08 0.03333333333333333 \
 1.933492857142857e-08 -0.03333333333333333 \
 1.934285714285714e-08 -0.03333333333333333 \
 1.934385714285714e-08 -0.1 \
 1.935178571428571e-08 -0.1 \
 1.935278571428571e-08 -0.03333333333333333 \
 1.936071428571428e-08 -0.03333333333333333 \
 1.936171428571428e-08 -0.03333333333333333 \
 1.936964285714285e-08 -0.03333333333333333 \
 1.937064285714285e-08 0.1 \
 1.937857142857143e-08 0.1 \
 1.937957142857143e-08 0.03333333333333333 \
 1.93875e-08 0.03333333333333333 \
 1.93885e-08 -0.03333333333333333 \
 1.939642857142857e-08 -0.03333333333333333 \
 1.939742857142857e-08 -0.1 \
 1.940535714285714e-08 -0.1 \
 1.940635714285714e-08 -0.1 \
 1.941428571428571e-08 -0.1 \
 1.941528571428571e-08 -0.1 \
 1.942321428571428e-08 -0.1 \
 1.942421428571429e-08 0.1 \
 1.943214285714286e-08 0.1 \
 1.943314285714286e-08 0.03333333333333333 \
 1.944107142857143e-08 0.03333333333333333 \
 1.944207142857143e-08 -0.1 \
 1.945e-08 -0.1 \
 1.9451e-08 0.03333333333333333 \
 1.945892857142857e-08 0.03333333333333333 \
 1.945992857142857e-08 0.03333333333333333 \
 1.946785714285714e-08 0.03333333333333333 \
 1.946885714285714e-08 0.1 \
 1.947678571428571e-08 0.1 \
 1.947778571428571e-08 -0.03333333333333333 \
 1.948571428571428e-08 -0.03333333333333333 \
 1.948671428571428e-08 0.1 \
 1.949464285714286e-08 0.1 \
 1.949564285714286e-08 -0.03333333333333333 \
 1.950357142857143e-08 -0.03333333333333333 \
 1.950457142857143e-08 -0.03333333333333333 \
 1.95125e-08 -0.03333333333333333 \
 1.95135e-08 0.1 \
 1.952142857142857e-08 0.1 \
 1.952242857142857e-08 0.03333333333333333 \
 1.953035714285714e-08 0.03333333333333333 \
 1.953135714285714e-08 0.03333333333333333 \
 1.953928571428571e-08 0.03333333333333333 \
 1.954028571428572e-08 -0.1 \
 1.954821428571428e-08 -0.1 \
 1.954921428571429e-08 0.03333333333333333 \
 1.955714285714285e-08 0.03333333333333333 \
 1.955814285714286e-08 0.1 \
 1.956607142857143e-08 0.1 \
 1.956707142857143e-08 -0.1 \
 1.9575e-08 -0.1 \
 1.9576e-08 0.1 \
 1.958392857142857e-08 0.1 \
 1.958492857142857e-08 0.03333333333333333 \
 1.959285714285714e-08 0.03333333333333333 \
 1.959385714285714e-08 0.03333333333333333 \
 1.960178571428571e-08 0.03333333333333333 \
 1.960278571428571e-08 -0.03333333333333333 \
 1.961071428571428e-08 -0.03333333333333333 \
 1.961171428571428e-08 0.1 \
 1.961964285714286e-08 0.1 \
 1.962064285714286e-08 0.1 \
 1.962857142857143e-08 0.1 \
 1.962957142857143e-08 -0.03333333333333333 \
 1.96375e-08 -0.03333333333333333 \
 1.96385e-08 -0.1 \
 1.964642857142857e-08 -0.1 \
 1.964742857142857e-08 0.03333333333333333 \
 1.965535714285714e-08 0.03333333333333333 \
 1.965635714285714e-08 -0.1 \
 1.966428571428571e-08 -0.1 \
 1.966528571428571e-08 0.03333333333333333 \
 1.967321428571428e-08 0.03333333333333333 \
 1.967421428571428e-08 -0.03333333333333333 \
 1.968214285714285e-08 -0.03333333333333333 \
 1.968314285714286e-08 -0.03333333333333333 \
 1.969107142857143e-08 -0.03333333333333333 \
 1.969207142857143e-08 -0.03333333333333333 \
 1.97e-08 -0.03333333333333333 \
 1.9701e-08 0.03333333333333333 \
 1.970892857142857e-08 0.03333333333333333 \
 1.970992857142857e-08 -0.03333333333333333 \
 1.971785714285714e-08 -0.03333333333333333 \
 1.971885714285714e-08 -0.03333333333333333 \
 1.972678571428571e-08 -0.03333333333333333 \
 1.972778571428571e-08 0.03333333333333333 \
 1.973571428571429e-08 0.03333333333333333 \
 1.973671428571429e-08 -0.03333333333333333 \
 1.974464285714286e-08 -0.03333333333333333 \
 1.974564285714286e-08 0.03333333333333333 \
 1.975357142857143e-08 0.03333333333333333 \
 1.975457142857143e-08 0.03333333333333333 \
 1.97625e-08 0.03333333333333333 \
 1.97635e-08 -0.1 \
 1.977142857142857e-08 -0.1 \
 1.977242857142857e-08 0.1 \
 1.978035714285714e-08 0.1 \
 1.978135714285714e-08 0.1 \
 1.978928571428571e-08 0.1 \
 1.979028571428571e-08 -0.03333333333333333 \
 1.979821428571428e-08 -0.03333333333333333 \
 1.979921428571428e-08 -0.1 \
 1.980714285714286e-08 -0.1 \
 1.980814285714286e-08 -0.1 \
 1.981607142857143e-08 -0.1 \
 1.981707142857143e-08 0.03333333333333333 \
 1.9825e-08 0.03333333333333333 \
 1.9826e-08 0.03333333333333333 \
 1.983392857142857e-08 0.03333333333333333 \
 1.983492857142857e-08 0.1 \
 1.984285714285714e-08 0.1 \
 1.984385714285714e-08 -0.1 \
 1.985178571428571e-08 -0.1 \
 1.985278571428571e-08 0.03333333333333333 \
 1.986071428571428e-08 0.03333333333333333 \
 1.986171428571429e-08 -0.1 \
 1.986964285714285e-08 -0.1 \
 1.987064285714286e-08 0.03333333333333333 \
 1.987857142857143e-08 0.03333333333333333 \
 1.987957142857143e-08 0.03333333333333333 \
 1.98875e-08 0.03333333333333333 \
 1.98885e-08 0.1 \
 1.989642857142857e-08 0.1 \
 1.989742857142857e-08 0.1 \
 1.990535714285714e-08 0.1 \
 1.990635714285714e-08 -0.03333333333333333 \
 1.991428571428571e-08 -0.03333333333333333 \
 1.991528571428571e-08 0.1 \
 1.992321428571428e-08 0.1 \
 1.992421428571428e-08 0.1 \
 1.993214285714286e-08 0.1 \
 1.993314285714286e-08 0.1 \
 1.994107142857143e-08 0.1 \
 1.994207142857143e-08 0.1 \
 1.995e-08 0.1 \
 1.9951e-08 -0.1 \
 1.995892857142857e-08 -0.1 \
 1.995992857142857e-08 0.1 \
 1.996785714285714e-08 0.1 \
 1.996885714285714e-08 0.03333333333333333 \
 1.997678571428571e-08 0.03333333333333333 \
 1.997778571428572e-08 -0.1 \
 1.998571428571428e-08 -0.1 \
 1.998671428571429e-08 -0.1 \
 1.999464285714285e-08 -0.1 \
 1.999564285714286e-08 0.03333333333333333 \
 2.000357142857143e-08 0.03333333333333333 \
 2.000457142857143e-08 0.1 \
 2.00125e-08 0.1 \
 2.00135e-08 -0.1 \
 2.002142857142857e-08 -0.1 \
 2.002242857142857e-08 -0.1 \
 2.003035714285714e-08 -0.1 \
 2.003135714285714e-08 0.1 \
 2.003928571428571e-08 0.1 \
 2.004028571428571e-08 0.03333333333333333 \
 2.004821428571429e-08 0.03333333333333333 \
 2.004921428571429e-08 0.03333333333333333 \
 2.005714285714286e-08 0.03333333333333333 \
 2.005814285714286e-08 -0.03333333333333333 \
 2.006607142857143e-08 -0.03333333333333333 \
 2.006707142857143e-08 -0.03333333333333333 \
 2.0075e-08 -0.03333333333333333 \
 2.0076e-08 -0.03333333333333333 \
 2.008392857142857e-08 -0.03333333333333333 \
 2.008492857142857e-08 0.1 \
 2.009285714285714e-08 0.1 \
 2.009385714285714e-08 -0.03333333333333333 \
 2.010178571428571e-08 -0.03333333333333333 \
 2.010278571428571e-08 -0.03333333333333333 \
 2.011071428571428e-08 -0.03333333333333333 \
 2.011171428571428e-08 -0.03333333333333333 \
 2.011964285714285e-08 -0.03333333333333333 \
 2.012064285714285e-08 0.1 \
 2.012857142857143e-08 0.1 \
 2.012957142857143e-08 0.1 \
 2.01375e-08 0.1 \
 2.01385e-08 -0.1 \
 2.014642857142857e-08 -0.1 \
 2.014742857142857e-08 -0.03333333333333333 \
 2.015535714285714e-08 -0.03333333333333333 \
 2.015635714285714e-08 0.1 \
 2.016428571428571e-08 0.1 \
 2.016528571428571e-08 -0.1 \
 2.017321428571428e-08 -0.1 \
 2.017421428571429e-08 0.1 \
 2.018214285714286e-08 0.1 \
 2.018314285714286e-08 -0.1 \
 2.019107142857143e-08 -0.1 \
 2.019207142857143e-08 -0.03333333333333333 \
 2.02e-08 -0.03333333333333333 \
 2.0201e-08 -0.1 \
 2.020892857142857e-08 -0.1 \
 2.020992857142857e-08 0.03333333333333333 \
 2.021785714285714e-08 0.03333333333333333 \
 2.021885714285714e-08 -0.03333333333333333 \
 2.022678571428571e-08 -0.03333333333333333 \
 2.022778571428571e-08 0.03333333333333333 \
 2.023571428571428e-08 0.03333333333333333 \
 2.023671428571428e-08 -0.03333333333333333 \
 2.024464285714286e-08 -0.03333333333333333 \
 2.024564285714286e-08 0.1 \
 2.025357142857143e-08 0.1 \
 2.025457142857143e-08 -0.03333333333333333 \
 2.02625e-08 -0.03333333333333333 \
 2.02635e-08 -0.03333333333333333 \
 2.027142857142857e-08 -0.03333333333333333 \
 2.027242857142857e-08 -0.1 \
 2.028035714285714e-08 -0.1 \
 2.028135714285714e-08 0.03333333333333333 \
 2.028928571428571e-08 0.03333333333333333 \
 2.029028571428571e-08 -0.03333333333333333 \
 2.029821428571428e-08 -0.03333333333333333 \
 2.029921428571429e-08 -0.03333333333333333 \
 2.030714285714285e-08 -0.03333333333333333 \
 2.030814285714286e-08 0.03333333333333333 \
 2.031607142857143e-08 0.03333333333333333 \
 2.031707142857143e-08 -0.03333333333333333 \
 2.0325e-08 -0.03333333333333333 \
 2.0326e-08 -0.1 \
 2.033392857142857e-08 -0.1 \
 2.033492857142857e-08 0.1 \
 2.034285714285714e-08 0.1 \
 2.034385714285714e-08 -0.1 \
 2.035178571428571e-08 -0.1 \
 2.035278571428571e-08 0.1 \
 2.036071428571428e-08 0.1 \
 2.036171428571428e-08 -0.03333333333333333 \
 2.036964285714286e-08 -0.03333333333333333 \
 2.037064285714286e-08 0.1 \
 2.037857142857143e-08 0.1 \
 2.037957142857143e-08 -0.03333333333333333 \
 2.03875e-08 -0.03333333333333333 \
 2.03885e-08 -0.03333333333333333 \
 2.039642857142857e-08 -0.03333333333333333 \
 2.039742857142857e-08 -0.1 \
 2.040535714285714e-08 -0.1 \
 2.040635714285714e-08 0.1 \
 2.041428571428571e-08 0.1 \
 2.041528571428571e-08 0.03333333333333333 \
 2.042321428571428e-08 0.03333333333333333 \
 2.042421428571429e-08 -0.03333333333333333 \
 2.043214285714285e-08 -0.03333333333333333 \
 2.043314285714286e-08 -0.03333333333333333 \
 2.044107142857143e-08 -0.03333333333333333 \
 2.044207142857143e-08 0.03333333333333333 \
 2.045e-08 0.03333333333333333 \
 2.0451e-08 0.1 \
 2.045892857142857e-08 0.1 \
 2.045992857142857e-08 -0.1 \
 2.046785714285714e-08 -0.1 \
 2.046885714285714e-08 0.1 \
 2.047678571428571e-08 0.1 \
 2.047778571428571e-08 0.03333333333333333 \
 2.048571428571429e-08 0.03333333333333333 \
 2.048671428571429e-08 0.03333333333333333 \
 2.049464285714286e-08 0.03333333333333333 \
 2.049564285714286e-08 -0.1 \
 2.050357142857143e-08 -0.1 \
 2.050457142857143e-08 0.03333333333333333 \
 2.05125e-08 0.03333333333333333 \
 2.05135e-08 0.03333333333333333 \
 2.052142857142857e-08 0.03333333333333333 \
 2.052242857142857e-08 -0.1 \
 2.053035714285714e-08 -0.1 \
 2.053135714285714e-08 0.1 \
 2.053928571428571e-08 0.1 \
 2.054028571428571e-08 0.03333333333333333 \
 2.054821428571428e-08 0.03333333333333333 \
 2.054921428571428e-08 0.1 \
 2.055714285714286e-08 0.1 \
 2.055814285714286e-08 0.03333333333333333 \
 2.056607142857143e-08 0.03333333333333333 \
 2.056707142857143e-08 0.1 \
 2.0575e-08 0.1 \
 2.0576e-08 -0.03333333333333333 \
 2.058392857142857e-08 -0.03333333333333333 \
 2.058492857142857e-08 -0.03333333333333333 \
 2.059285714285714e-08 -0.03333333333333333 \
 2.059385714285714e-08 -0.1 \
 2.060178571428571e-08 -0.1 \
 2.060278571428571e-08 -0.03333333333333333 \
 2.061071428571428e-08 -0.03333333333333333 \
 2.061171428571429e-08 -0.03333333333333333 \
 2.061964285714285e-08 -0.03333333333333333 \
 2.062064285714286e-08 -0.1 \
 2.062857142857143e-08 -0.1 \
 2.062957142857143e-08 0.03333333333333333 \
 2.06375e-08 0.03333333333333333 \
 2.06385e-08 -0.03333333333333333 \
 2.064642857142857e-08 -0.03333333333333333 \
 2.064742857142857e-08 -0.1 \
 2.065535714285714e-08 -0.1 \
 2.065635714285714e-08 0.03333333333333333 \
 2.066428571428571e-08 0.03333333333333333 \
 2.066528571428571e-08 0.03333333333333333 \
 2.067321428571428e-08 0.03333333333333333 \
 2.067421428571428e-08 -0.03333333333333333 \
 2.068214285714286e-08 -0.03333333333333333 \
 2.068314285714286e-08 0.1 \
 2.069107142857143e-08 0.1 \
 2.069207142857143e-08 -0.03333333333333333 \
 2.07e-08 -0.03333333333333333 \
 2.0701e-08 -0.1 \
 2.070892857142857e-08 -0.1 \
 2.070992857142857e-08 0.03333333333333333 \
 2.071785714285714e-08 0.03333333333333333 \
 2.071885714285714e-08 -0.03333333333333333 \
 2.072678571428571e-08 -0.03333333333333333 \
 2.072778571428572e-08 0.1 \
 2.073571428571428e-08 0.1 \
 2.073671428571429e-08 0.1 \
 2.074464285714285e-08 0.1 \
 2.074564285714286e-08 -0.1 \
 2.075357142857143e-08 -0.1 \
 2.075457142857143e-08 -0.03333333333333333 \
 2.07625e-08 -0.03333333333333333 \
 2.07635e-08 -0.03333333333333333 \
 2.077142857142857e-08 -0.03333333333333333 \
 2.077242857142857e-08 0.03333333333333333 \
 2.078035714285714e-08 0.03333333333333333 \
 2.078135714285714e-08 -0.03333333333333333 \
 2.078928571428571e-08 -0.03333333333333333 \
 2.079028571428571e-08 0.1 \
 2.079821428571428e-08 0.1 \
 2.079921428571428e-08 0.03333333333333333 \
 2.080714285714286e-08 0.03333333333333333 \
 2.080814285714286e-08 0.03333333333333333 \
 2.081607142857143e-08 0.03333333333333333 \
 2.081707142857143e-08 0.03333333333333333 \
 2.0825e-08 0.03333333333333333 \
 2.0826e-08 -0.03333333333333333 \
 2.083392857142857e-08 -0.03333333333333333 \
 2.083492857142857e-08 -0.1 \
 2.084285714285714e-08 -0.1 \
 2.084385714285714e-08 -0.1 \
 2.085178571428571e-08 -0.1 \
 2.085278571428571e-08 -0.03333333333333333 \
 2.086071428571428e-08 -0.03333333333333333 \
 2.086171428571428e-08 -0.03333333333333333 \
 2.086964285714285e-08 -0.03333333333333333 \
 2.087064285714286e-08 0.03333333333333333 \
 2.087857142857143e-08 0.03333333333333333 \
 2.087957142857143e-08 -0.03333333333333333 \
 2.08875e-08 -0.03333333333333333 \
 2.08885e-08 -0.1 \
 2.089642857142857e-08 -0.1 \
 2.089742857142857e-08 -0.1 \
 2.090535714285714e-08 -0.1 \
 2.090635714285714e-08 0.03333333333333333 \
 2.091428571428571e-08 0.03333333333333333 \
 2.091528571428571e-08 -0.03333333333333333 \
 2.092321428571429e-08 -0.03333333333333333 \
 2.092421428571429e-08 -0.03333333333333333 \
 2.093214285714286e-08 -0.03333333333333333 \
 2.093314285714286e-08 -0.1 \
 2.094107142857143e-08 -0.1 \
 2.094207142857143e-08 0.1 \
 2.095e-08 0.1 \
 2.0951e-08 -0.03333333333333333 \
 2.095892857142857e-08 -0.03333333333333333 \
 2.095992857142857e-08 -0.03333333333333333 \
 2.096785714285714e-08 -0.03333333333333333 \
 2.096885714285714e-08 0.1 \
 2.097678571428571e-08 0.1 \
 2.097778571428571e-08 -0.03333333333333333 \
 2.098571428571428e-08 -0.03333333333333333 \
 2.098671428571428e-08 0.1 \
 2.099464285714286e-08 0.1 \
 2.099564285714286e-08 -0.03333333333333333 \
 2.100357142857143e-08 -0.03333333333333333 \
 2.100457142857143e-08 0.1 \
 2.10125e-08 0.1 \
 2.10135e-08 0.1 \
 2.102142857142857e-08 0.1 \
 2.102242857142857e-08 0.1 \
 2.103035714285714e-08 0.1 \
 2.103135714285714e-08 -0.03333333333333333 \
 2.103928571428571e-08 -0.03333333333333333 \
 2.104028571428571e-08 0.1 \
 2.104821428571428e-08 0.1 \
 2.104921428571429e-08 -0.1 \
 2.105714285714285e-08 -0.1 \
 2.105814285714286e-08 0.03333333333333333 \
 2.106607142857143e-08 0.03333333333333333 \
 2.106707142857143e-08 0.1 \
 2.1075e-08 0.1 \
 2.1076e-08 0.1 \
 2.108392857142857e-08 0.1 \
 2.108492857142857e-08 0.1 \
 2.109285714285714e-08 0.1 \
 2.109385714285714e-08 0.03333333333333333 \
 2.110178571428571e-08 0.03333333333333333 \
 2.110278571428571e-08 0.1 \
 2.111071428571428e-08 0.1 \
 2.111171428571428e-08 0.1 \
 2.111964285714286e-08 0.1 \
 2.112064285714286e-08 -0.1 \
 2.112857142857143e-08 -0.1 \
 2.112957142857143e-08 0.03333333333333333 \
 2.11375e-08 0.03333333333333333 \
 2.11385e-08 -0.03333333333333333 \
 2.114642857142857e-08 -0.03333333333333333 \
 2.114742857142857e-08 0.1 \
 2.115535714285714e-08 0.1 \
 2.115635714285714e-08 0.1 \
 2.116428571428571e-08 0.1 \
 2.116528571428571e-08 -0.1 \
 2.117321428571428e-08 -0.1 \
 2.117421428571429e-08 -0.03333333333333333 \
 2.118214285714285e-08 -0.03333333333333333 \
 2.118314285714286e-08 -0.03333333333333333 \
 2.119107142857143e-08 -0.03333333333333333 \
 2.119207142857143e-08 -0.03333333333333333 \
 2.12e-08 -0.03333333333333333 \
 2.1201e-08 -0.1 \
 2.120892857142857e-08 -0.1 \
 2.120992857142857e-08 -0.03333333333333333 \
 2.121785714285714e-08 -0.03333333333333333 \
 2.121885714285714e-08 0.03333333333333333 \
 2.122678571428571e-08 0.03333333333333333 \
 2.122778571428571e-08 0.03333333333333333 \
 2.123571428571429e-08 0.03333333333333333 \
 2.123671428571429e-08 -0.1 \
 2.124464285714286e-08 -0.1 \
 2.124564285714286e-08 -0.1 \
 2.125357142857143e-08 -0.1 \
 2.125457142857143e-08 0.1 \
 2.12625e-08 0.1 \
 2.12635e-08 -0.1 \
 2.127142857142857e-08 -0.1 \
 2.127242857142857e-08 0.1 \
 2.128035714285714e-08 0.1 \
 2.128135714285714e-08 0.03333333333333333 \
 2.128928571428571e-08 0.03333333333333333 \
 2.129028571428571e-08 -0.1 \
 2.129821428571428e-08 -0.1 \
 2.129921428571428e-08 -0.1 \
 2.130714285714285e-08 -0.1 \
 2.130814285714285e-08 0.1 \
 2.131607142857143e-08 0.1 \
 2.131707142857143e-08 -0.1 \
 2.1325e-08 -0.1 \
 2.1326e-08 -0.1 \
 2.133392857142857e-08 -0.1 \
 2.133492857142857e-08 -0.03333333333333333 \
 2.134285714285714e-08 -0.03333333333333333 \
 2.134385714285714e-08 0.1 \
 2.135178571428571e-08 0.1 \
 2.135278571428571e-08 -0.1 \
 2.136071428571428e-08 -0.1 \
 2.136171428571429e-08 0.1 \
 2.136964285714286e-08 0.1 \
 2.137064285714286e-08 0.1 \
 2.137857142857143e-08 0.1 \
 2.137957142857143e-08 -0.1 \
 2.13875e-08 -0.1 \
 2.13885e-08 -0.03333333333333333 \
 2.139642857142857e-08 -0.03333333333333333 \
 2.139742857142857e-08 -0.03333333333333333 \
 2.140535714285714e-08 -0.03333333333333333 \
 2.140635714285714e-08 0.03333333333333333 \
 2.141428571428571e-08 0.03333333333333333 \
 2.141528571428571e-08 0.1 \
 2.142321428571428e-08 0.1 \
 2.142421428571428e-08 -0.1 \
 2.143214285714286e-08 -0.1 \
 2.143314285714286e-08 0.1 \
 2.144107142857143e-08 0.1 \
 2.144207142857143e-08 -0.1 \
 2.145e-08 -0.1 \
 2.1451e-08 -0.1 \
 2.145892857142857e-08 -0.1 \
 2.145992857142857e-08 0.1 \
 2.146785714285714e-08 0.1 \
 2.146885714285714e-08 0.1 \
 2.147678571428571e-08 0.1 \
 2.147778571428571e-08 -0.03333333333333333 \
 2.148571428571428e-08 -0.03333333333333333 \
 2.148671428571429e-08 0.03333333333333333 \
 2.149464285714285e-08 0.03333333333333333 \
 2.149564285714286e-08 -0.1 \
 2.150357142857143e-08 -0.1 \
 2.150457142857143e-08 -0.03333333333333333 \
 2.15125e-08 -0.03333333333333333 \
 2.15135e-08 -0.1 \
 2.152142857142857e-08 -0.1 \
 2.152242857142857e-08 -0.1 \
 2.153035714285714e-08 -0.1 \
 2.153135714285714e-08 0.03333333333333333 \
 2.153928571428571e-08 0.03333333333333333 \
 2.154028571428571e-08 0.03333333333333333 \
 2.154821428571428e-08 0.03333333333333333 \
 2.154921428571428e-08 0.1 \
 2.155714285714286e-08 0.1 \
 2.155814285714286e-08 -0.1 \
 2.156607142857143e-08 -0.1 \
 2.156707142857143e-08 -0.03333333333333333 \
 2.1575e-08 -0.03333333333333333 \
 2.1576e-08 0.03333333333333333 \
 2.158392857142857e-08 0.03333333333333333 \
 2.158492857142857e-08 0.1 \
 2.159285714285714e-08 0.1 \
 2.159385714285714e-08 0.03333333333333333 \
 2.160178571428571e-08 0.03333333333333333 \
 2.160278571428571e-08 -0.03333333333333333 \
 2.161071428571428e-08 -0.03333333333333333 \
 2.161171428571428e-08 0.03333333333333333 \
 2.161964285714285e-08 0.03333333333333333 \
 2.162064285714286e-08 -0.03333333333333333 \
 2.162857142857143e-08 -0.03333333333333333 \
 2.162957142857143e-08 0.1 \
 2.16375e-08 0.1 \
 2.16385e-08 0.1 \
 2.164642857142857e-08 0.1 \
 2.164742857142857e-08 0.1 \
 2.165535714285714e-08 0.1 \
 2.165635714285714e-08 -0.1 \
 2.166428571428571e-08 -0.1 \
 2.166528571428571e-08 -0.1 \
 2.167321428571429e-08 -0.1 \
 2.167421428571429e-08 0.1 \
 2.168214285714286e-08 0.1 \
 2.168314285714286e-08 0.1 \
 2.169107142857143e-08 0.1 \
 2.169207142857143e-08 0.1 \
 2.17e-08 0.1 \
 2.1701e-08 0.1 \
 2.170892857142857e-08 0.1 \
 2.170992857142857e-08 0.1 \
 2.171785714285714e-08 0.1 \
 2.171885714285714e-08 -0.03333333333333333 \
 2.172678571428571e-08 -0.03333333333333333 \
 2.172778571428571e-08 0.03333333333333333 \
 2.173571428571428e-08 0.03333333333333333 \
 2.173671428571428e-08 -0.03333333333333333 \
 2.174464285714286e-08 -0.03333333333333333 \
 2.174564285714286e-08 -0.1 \
 2.175357142857143e-08 -0.1 \
 2.175457142857143e-08 -0.1 \
 2.17625e-08 -0.1 \
 2.17635e-08 0.03333333333333333 \
 2.177142857142857e-08 0.03333333333333333 \
 2.177242857142857e-08 0.1 \
 2.178035714285714e-08 0.1 \
 2.178135714285714e-08 -0.1 \
 2.178928571428571e-08 -0.1 \
 2.179028571428571e-08 -0.03333333333333333 \
 2.179821428571428e-08 -0.03333333333333333 \
 2.179921428571429e-08 -0.1 \
 2.180714285714285e-08 -0.1 \
 2.180814285714286e-08 -0.03333333333333333 \
 2.181607142857143e-08 -0.03333333333333333 \
 2.181707142857143e-08 0.03333333333333333 \
 2.1825e-08 0.03333333333333333 \
 2.1826e-08 -0.03333333333333333 \
 2.183392857142857e-08 -0.03333333333333333 \
 2.183492857142857e-08 0.1 \
 2.184285714285714e-08 0.1 \
 2.184385714285714e-08 0.03333333333333333 \
 2.185178571428571e-08 0.03333333333333333 \
 2.185278571428571e-08 0.03333333333333333 \
 2.186071428571428e-08 0.03333333333333333 \
 2.186171428571428e-08 -0.1 \
 2.186964285714286e-08 -0.1 \
 2.187064285714286e-08 0.03333333333333333 \
 2.187857142857143e-08 0.03333333333333333 \
 2.187957142857143e-08 -0.03333333333333333 \
 2.18875e-08 -0.03333333333333333 \
 2.18885e-08 0.03333333333333333 \
 2.189642857142857e-08 0.03333333333333333 \
 2.189742857142857e-08 0.03333333333333333 \
 2.190535714285714e-08 0.03333333333333333 \
 2.190635714285714e-08 0.03333333333333333 \
 ]
CHR1m (PAM4_src_m CH1_m) resistor r=100
CHC1m (CH1_m X_cm) capacitor c=8.526157665637249e-14
CHB1m (CHB_m X_cm CH1_m X_cm) vcvs gain=1
CHR2m (CHB_m CH2_m) resistor r=100
CHC2m (CH2_m X_cm) capacitor c=8.526157665637249e-14
CHB2m (X_im X_cm CH2_m X_cm) vcvs gain=1
VBANK (bankvdd 0) vsource dc=.9
VNBIAS (nbias 0) vsource dc=0.5
VPBIAS (pbias 0) vsource dc=0.4
VCOMP (compvdd 0) vsource dc=.9
VLOGIC (logicvdd 0) vsource dc=.9
subckt COMPLOAD (inp inn avdd bvdd)
M1 (p inp tail 0) nmos_lvt l=30n w=1u multi=1 nf=1 sd=100n ad=7.5e-14 as=7.5e-14 pd=2.15u ps=2.15u nrd=0.289519 nrs=0.289519 sa=75.0n sb=75.0n sa1=75.0n sa2=75.0n sa3=75.0n sa4=75.0n sb1=75.0n sb2=75.0n sb3=75.0n spa=100n spa1=100n spa2=100n spa3=100n sap=91.9776n sapb=114.444n spba=115.715n spba1=117.043n dfm_flag=0 _ccoflag=1 _rcoflag=1 _rgflag=1 spmt=1.11111e+15 spomt=0 spomt1=1.11111e+60 spmb=1.11111e+15 spomb=0 spomb1=1.11111e+60
M2 (q inn tail 0) nmos_lvt l=30n w=1u multi=1 nf=1 sd=100n ad=7.5e-14 as=7.5e-14 pd=2.15u ps=2.15u nrd=0.289519 nrs=0.289519 sa=75.0n sb=75.0n sa1=75.0n sa2=75.0n sa3=75.0n sa4=75.0n sb1=75.0n sb2=75.0n sb3=75.0n spa=100n spa1=100n spa2=100n spa3=100n sap=91.9776n sapb=114.444n spba=115.715n spba1=117.043n dfm_flag=0 _ccoflag=1 _rcoflag=1 _rgflag=1 spmt=1.11111e+15 spomt=0 spomt1=1.11111e+60 spmb=1.11111e+15 spomb=0 spomb1=1.11111e+60
M3 (x y p 0) nmos_lvt l=30n w=500n multi=1 nf=1 sd=100n ad=3.75e-14 as=3.75e-14 pd=1.15u ps=1.15u nrd=0.662935 nrs=0.662935 sa=75.0n sb=75.0n sa1=75.0n sa2=75.0n sa3=75.0n sa4=75.0n sb1=75.0n sb2=75.0n sb3=75.0n spa=100n spa1=100n spa2=100n spa3=100n sap=91.9776n sapb=114.444n spba=115.715n spba1=117.043n dfm_flag=0 _ccoflag=1 _rcoflag=1 _rgflag=1 spmt=1.11111e+15 spomt=0 spomt1=1.11111e+60 spmb=1.11111e+15 spomb=0 spomb1=1.11111e+60
M4 (y x q 0) nmos_lvt l=30n w=500n multi=1 nf=1 sd=100n ad=3.75e-14 as=3.75e-14 pd=1.15u ps=1.15u nrd=0.662935 nrs=0.662935 sa=75.0n sb=75.0n sa1=75.0n sa2=75.0n sa3=75.0n sa4=75.0n sb1=75.0n sb2=75.0n sb3=75.0n spa=100n spa1=100n spa2=100n spa3=100n sap=91.9776n sapb=114.444n spba=115.715n spba1=117.043n dfm_flag=0 _ccoflag=1 _rcoflag=1 _rgflag=1 spmt=1.11111e+15 spomt=0 spomt1=1.11111e+60 spmb=1.11111e+15 spomb=0 spomb1=1.11111e+60
M5 (x y avdd avdd) pmos_lvt l=30n w=500n multi=1 nf=1 sd=100n ad=3.75e-14 as=3.75e-14 pd=1.15u ps=1.15u nrd=0.383209 nrs=0.383209 sa=75.0n sb=75.0n sa1=75.0n sa2=75.0n sa3=75.0n sa4=75.0n sb1=75.0n sb2=75.0n sb3=75.0n spa=100n spa1=100n spa2=100n spa3=100n sap=91.9776n sapb=114.444n spba=115.715n spba1=117.043n dfm_flag=0 _ccoflag=1 _rcoflag=1 _rgflag=1 spmt=1.11111e+15 spomt=0 spomt1=1.11111e+60 spmb=1.11111e+15 spomb=0 spomb1=1.11111e+60
M6 (y x avdd avdd) pmos_lvt l=30n w=500n multi=1 nf=1 sd=100n ad=3.75e-14 as=3.75e-14 pd=1.15u ps=1.15u nrd=0.383209 nrs=0.383209 sa=75.0n sb=75.0n sa1=75.0n sa2=75.0n sa3=75.0n sa4=75.0n sb1=75.0n sb2=75.0n sb3=75.0n spa=100n spa1=100n spa2=100n spa3=100n sap=91.9776n sapb=114.444n spba=115.715n spba1=117.043n dfm_flag=0 _ccoflag=1 _rcoflag=1 _rgflag=1 spmt=1.11111e+15 spomt=0 spomt1=1.11111e+60 spmb=1.11111e+15 spomb=0 spomb1=1.11111e+60
M7 (tail 0 0 0) nmos_lvt l=30n w=3u multi=1 nf=1 sd=100n ad=2.25e-13 as=2.25e-13 pd=6.15u ps=6.15u nrd=0.096480 nrs=0.096480 sa=75.0n sb=75.0n sa1=75.0n sa2=75.0n sa3=75.0n sa4=75.0n sb1=75.0n sb2=75.0n sb3=75.0n spa=100n spa1=100n spa2=100n spa3=100n sap=91.9776n sapb=114.444n spba=115.715n spba1=117.043n dfm_flag=0 _ccoflag=1 _rcoflag=1 _rgflag=1 spmt=1.11111e+15 spomt=0 spomt1=1.11111e+60 spmb=1.11111e+15 spomb=0 spomb1=1.11111e+60
SP (p 0 avdd avdd) pmos_lvt l=30n w=500n multi=1 nf=1 sd=100n ad=3.75e-14 as=3.75e-14 pd=1.15u ps=1.15u nrd=0.383209 nrs=0.383209 sa=75.0n sb=75.0n sa1=75.0n sa2=75.0n sa3=75.0n sa4=75.0n sb1=75.0n sb2=75.0n sb3=75.0n spa=100n spa1=100n spa2=100n spa3=100n sap=91.9776n sapb=114.444n spba=115.715n spba1=117.043n dfm_flag=0 _ccoflag=1 _rcoflag=1 _rgflag=1 spmt=1.11111e+15 spomt=0 spomt1=1.11111e+60 spmb=1.11111e+15 spomb=0 spomb1=1.11111e+60
SQ (q 0 avdd avdd) pmos_lvt l=30n w=500n multi=1 nf=1 sd=100n ad=3.75e-14 as=3.75e-14 pd=1.15u ps=1.15u nrd=0.383209 nrs=0.383209 sa=75.0n sb=75.0n sa1=75.0n sa2=75.0n sa3=75.0n sa4=75.0n sb1=75.0n sb2=75.0n sb3=75.0n spa=100n spa1=100n spa2=100n spa3=100n sap=91.9776n sapb=114.444n spba=115.715n spba1=117.043n dfm_flag=0 _ccoflag=1 _rcoflag=1 _rgflag=1 spmt=1.11111e+15 spomt=0 spomt1=1.11111e+60 spmb=1.11111e+15 spomb=0 spomb1=1.11111e+60
SX (x 0 avdd avdd) pmos_lvt l=30n w=500n multi=1 nf=1 sd=100n ad=3.75e-14 as=3.75e-14 pd=1.15u ps=1.15u nrd=0.383209 nrs=0.383209 sa=75.0n sb=75.0n sa1=75.0n sa2=75.0n sa3=75.0n sa4=75.0n sb1=75.0n sb2=75.0n sb3=75.0n spa=100n spa1=100n spa2=100n spa3=100n sap=91.9776n sapb=114.444n spba=115.715n spba1=117.043n dfm_flag=0 _ccoflag=1 _rcoflag=1 _rgflag=1 spmt=1.11111e+15 spomt=0 spomt1=1.11111e+60 spmb=1.11111e+15 spomb=0 spomb1=1.11111e+60
SY (y 0 avdd avdd) pmos_lvt l=30n w=500n multi=1 nf=1 sd=100n ad=3.75e-14 as=3.75e-14 pd=1.15u ps=1.15u nrd=0.383209 nrs=0.383209 sa=75.0n sb=75.0n sa1=75.0n sa2=75.0n sa3=75.0n sa4=75.0n sb1=75.0n sb2=75.0n sb3=75.0n spa=100n spa1=100n spa2=100n spa3=100n sap=91.9776n sapb=114.444n spba=115.715n spba1=117.043n dfm_flag=0 _ccoflag=1 _rcoflag=1 _rgflag=1 spmt=1.11111e+15 spomt=0 spomt1=1.11111e+60 spmb=1.11111e+15 spomb=0 spomb1=1.11111e+60
MEQPQ (p 0 q avdd) pmos_lvt l=30n w=240.0n multi=1 nf=1 sd=100n ad=1.8e-14 as=1.8e-14 pd=630.0n ps=630.0n nrd=0.766665 nrs=0.766665 sa=75.0n sb=75.0n sa1=75.0n sa2=75.0n sa3=75.0n sa4=75.0n sb1=75.0n sb2=75.0n sb3=75.0n spa=100n spa1=100n spa2=100n spa3=100n sap=91.9776n sapb=114.444n spba=115.715n spba1=117.043n dfm_flag=0 _ccoflag=1 _rcoflag=1 _rgflag=1 spmt=1.11111e+15 spomt=0 spomt1=1.11111e+60 spmb=1.11111e+15 spomb=0 spomb1=1.11111e+60
MEQXY (x 0 y avdd) pmos_lvt l=30n w=240.0n multi=1 nf=1 sd=100n ad=1.8e-14 as=1.8e-14 pd=630.0n ps=630.0n nrd=0.766665 nrs=0.766665 sa=75.0n sb=75.0n sa1=75.0n sa2=75.0n sa3=75.0n sa4=75.0n sb1=75.0n sb2=75.0n sb3=75.0n spa=100n spa1=100n spa2=100n spa3=100n sap=91.9776n sapb=114.444n spba=115.715n spba1=117.043n dfm_flag=0 _ccoflag=1 _rcoflag=1 _rgflag=1 spmt=1.11111e+15 spomt=0 spomt1=1.11111e+60 spmb=1.11111e+15 spomb=0 spomb1=1.11111e+60
BNbx (bx x 0 0) nmos_lvt l=30n w=240.0n multi=1 nf=1 sd=100n ad=1.8e-14 as=1.8e-14 pd=630.0n ps=630.0n nrd=1.326151 nrs=1.326151 sa=75.0n sb=75.0n sa1=75.0n sa2=75.0n sa3=75.0n sa4=75.0n sb1=75.0n sb2=75.0n sb3=75.0n spa=100n spa1=100n spa2=100n spa3=100n sap=91.9776n sapb=114.444n spba=115.715n spba1=117.043n dfm_flag=0 _ccoflag=1 _rcoflag=1 _rgflag=1 spmt=1.11111e+15 spomt=0 spomt1=1.11111e+60 spmb=1.11111e+15 spomb=0 spomb1=1.11111e+60
BPbx (bx x bvdd bvdd) pmos_lvt l=30n w=500n multi=1 nf=1 sd=100n ad=3.75e-14 as=3.75e-14 pd=1.15u ps=1.15u nrd=0.383209 nrs=0.383209 sa=75.0n sb=75.0n sa1=75.0n sa2=75.0n sa3=75.0n sa4=75.0n sb1=75.0n sb2=75.0n sb3=75.0n spa=100n spa1=100n spa2=100n spa3=100n sap=91.9776n sapb=114.444n spba=115.715n spba1=117.043n dfm_flag=0 _ccoflag=1 _rcoflag=1 _rgflag=1 spmt=1.11111e+15 spomt=0 spomt1=1.11111e+60 spmb=1.11111e+15 spomb=0 spomb1=1.11111e+60
BNby (by y 0 0) nmos_lvt l=30n w=240.0n multi=1 nf=1 sd=100n ad=1.8e-14 as=1.8e-14 pd=630.0n ps=630.0n nrd=1.326151 nrs=1.326151 sa=75.0n sb=75.0n sa1=75.0n sa2=75.0n sa3=75.0n sa4=75.0n sb1=75.0n sb2=75.0n sb3=75.0n spa=100n spa1=100n spa2=100n spa3=100n sap=91.9776n sapb=114.444n spba=115.715n spba1=117.043n dfm_flag=0 _ccoflag=1 _rcoflag=1 _rgflag=1 spmt=1.11111e+15 spomt=0 spomt1=1.11111e+60 spmb=1.11111e+15 spomb=0 spomb1=1.11111e+60
BPby (by y bvdd bvdd) pmos_lvt l=30n w=500n multi=1 nf=1 sd=100n ad=3.75e-14 as=3.75e-14 pd=1.15u ps=1.15u nrd=0.383209 nrs=0.383209 sa=75.0n sb=75.0n sa1=75.0n sa2=75.0n sa3=75.0n sa4=75.0n sb1=75.0n sb2=75.0n sb3=75.0n spa=100n spa1=100n spa2=100n spa3=100n sap=91.9776n sapb=114.444n spba=115.715n spba1=117.043n dfm_flag=0 _ccoflag=1 _rcoflag=1 _rgflag=1 spmt=1.11111e+15 spomt=0 spomt1=1.11111e+60 spmb=1.11111e+15 spomb=0 spomb1=1.11111e+60
CBX (bx 0) capacitor c=1f
CBY (by 0) capacitor c=1f
ends COMPLOAD
B0_ck0V (B0_ck0 0) vsource type=pulse val0=0 val1=0.9 delay=1.042321428571429e-10 rise=1e-12 fall=1e-12 width=6.471429999999999e-11 period=5.714288e-10
B0_kb0V (B0_kb0 0) vsource type=pulse val0=0.9 val1=0 delay=1.042321428571429e-10 rise=1e-12 fall=1e-12 width=6.471429999999999e-11 period=5.714288e-10
B0_ck1V (B0_ck1 0) vsource type=pulse val0=0 val1=0.9 delay=1.756607428571429e-10 rise=1e-12 fall=1e-12 width=6.471429999999999e-11 period=5.714288e-10
B0_kb1V (B0_kb1 0) vsource type=pulse val0=0.9 val1=0 delay=1.756607428571429e-10 rise=1e-12 fall=1e-12 width=6.471429999999999e-11 period=5.714288e-10
B0_ck2V (B0_ck2 0) vsource type=pulse val0=0 val1=0.9 delay=2.470893428571429e-10 rise=1e-12 fall=1e-12 width=6.471429999999999e-11 period=5.714288e-10
B0_kb2V (B0_kb2 0) vsource type=pulse val0=0.9 val1=0 delay=2.470893428571429e-10 rise=1e-12 fall=1e-12 width=6.471429999999999e-11 period=5.714288e-10
B0_ck3V (B0_ck3 0) vsource type=pulse val0=0 val1=0.9 delay=3.185179428571429e-10 rise=1e-12 fall=1e-12 width=6.471429999999999e-11 period=5.714288e-10
B0_kb3V (B0_kb3 0) vsource type=pulse val0=0.9 val1=0 delay=3.185179428571429e-10 rise=1e-12 fall=1e-12 width=6.471429999999999e-11 period=5.714288e-10
B0_ck4V (B0_ck4 0) vsource type=pulse val0=0 val1=0.9 delay=3.899465428571429e-10 rise=1e-12 fall=1e-12 width=6.471429999999999e-11 period=5.714288e-10
B0_kb4V (B0_kb4 0) vsource type=pulse val0=0.9 val1=0 delay=3.899465428571429e-10 rise=1e-12 fall=1e-12 width=6.471429999999999e-11 period=5.714288e-10
B0_ck5V (B0_ck5 0) vsource type=pulse val0=0 val1=0.9 delay=4.613751428571429e-10 rise=1e-12 fall=1e-12 width=6.471429999999999e-11 period=5.714288e-10
B0_kb5V (B0_kb5 0) vsource type=pulse val0=0.9 val1=0 delay=4.613751428571429e-10 rise=1e-12 fall=1e-12 width=6.471429999999999e-11 period=5.714288e-10
B0_ck6V (B0_ck6 0) vsource type=pulse val0=0 val1=0.9 delay=5.328037428571428e-10 rise=1e-12 fall=1e-12 width=6.471429999999999e-11 period=5.714288e-10
B0_kb6V (B0_kb6 0) vsource type=pulse val0=0.9 val1=0 delay=5.328037428571428e-10 rise=1e-12 fall=1e-12 width=6.471429999999999e-11 period=5.714288e-10
B0_ck7V (B0_ck7 0) vsource type=pulse val0=0 val1=0.9 delay=6.042323428571428e-10 rise=1e-12 fall=1e-12 width=6.471429999999999e-11 period=5.714288e-10
B0_kb7V (B0_kb7 0) vsource type=pulse val0=0.9 val1=0 delay=6.042323428571428e-10 rise=1e-12 fall=1e-12 width=6.471429999999999e-11 period=5.714288e-10
RB0_Lp (bankvdd B0_fp) resistor r=500
B0_Fp (B0_fp X_h0p B0_ep 0) nmos_lvt l=30n w=2u multi=1 nf=1 sd=100n ad=1.5e-13 as=1.5e-13 pd=4.15u ps=4.15u nrd=0.144730 nrs=0.144730 sa=75.0n sb=75.0n sa1=75.0n sa2=75.0n sa3=75.0n sa4=75.0n sb1=75.0n sb2=75.0n sb3=75.0n spa=100n spa1=100n spa2=100n spa3=100n sap=91.9776n sapb=114.444n spba=115.715n spba1=117.043n dfm_flag=0 _ccoflag=1 _rcoflag=1 _rgflag=1 spmt=1.11111e+15 spomt=0 spomt1=1.11111e+60 spmb=1.11111e+15 spomb=0 spomb1=1.11111e+60
B0_Tp (B0_ep nbias 0 0) nmos_lvt l=60n w=2u multi=1 nf=1 sd=100n ad=1.5e-13 as=1.5e-13 pd=4.15u ps=4.15u nrd=0.144730 nrs=0.144730 sa=75.0n sb=75.0n sa1=75.0n sa2=75.0n sa3=75.0n sa4=75.0n sb1=75.0n sb2=75.0n sb3=75.0n spa=100n spa1=100n spa2=100n spa3=100n sap=91.9776n sapb=120.93n spba=121.82n spba1=124.403n dfm_flag=0 _ccoflag=1 _rcoflag=1 _rgflag=1 spmt=1.11111e+15 spomt=0 spomt1=1.11111e+60 spmb=1.11111e+15 spomb=0 spomb1=1.11111e+60
B0_SN0p (B0_h0p B0_ck0 B0_fp 0) nmos_lvt l=30n w=2u multi=1 nf=1 sd=100n ad=1.5e-13 as=1.5e-13 pd=4.15u ps=4.15u nrd=0.144730 nrs=0.144730 sa=75.0n sb=75.0n sa1=75.0n sa2=75.0n sa3=75.0n sa4=75.0n sb1=75.0n sb2=75.0n sb3=75.0n spa=100n spa1=100n spa2=100n spa3=100n sap=91.9776n sapb=114.444n spba=115.715n spba1=117.043n dfm_flag=0 _ccoflag=1 _rcoflag=1 _rgflag=1 spmt=1.11111e+15 spomt=0 spomt1=1.11111e+60 spmb=1.11111e+15 spomb=0 spomb1=1.11111e+60
B0_SP0p (B0_h0p B0_kb0 B0_fp bankvdd) pmos_lvt l=30n w=2u multi=1 nf=1 sd=100n ad=1.5e-13 as=1.5e-13 pd=4.15u ps=4.15u nrd=0.082877 nrs=0.082877 sa=75.0n sb=75.0n sa1=75.0n sa2=75.0n sa3=75.0n sa4=75.0n sb1=75.0n sb2=75.0n sb3=75.0n spa=100n spa1=100n spa2=100n spa3=100n sap=91.9776n sapb=114.444n spba=115.715n spba1=117.043n dfm_flag=0 _ccoflag=1 _rcoflag=1 _rgflag=1 spmt=1.11111e+15 spomt=0 spomt1=1.11111e+60 spmb=1.11111e+15 spomb=0 spomb1=1.11111e+60
B0_CH0p (B0_h0p 0) capacitor c=2.5e-14
B0_RH0p (B0_h0p B0_fp) resistor r=1T
B0_SN1p (B0_h1p B0_ck1 B0_fp 0) nmos_lvt l=30n w=2u multi=1 nf=1 sd=100n ad=1.5e-13 as=1.5e-13 pd=4.15u ps=4.15u nrd=0.144730 nrs=0.144730 sa=75.0n sb=75.0n sa1=75.0n sa2=75.0n sa3=75.0n sa4=75.0n sb1=75.0n sb2=75.0n sb3=75.0n spa=100n spa1=100n spa2=100n spa3=100n sap=91.9776n sapb=114.444n spba=115.715n spba1=117.043n dfm_flag=0 _ccoflag=1 _rcoflag=1 _rgflag=1 spmt=1.11111e+15 spomt=0 spomt1=1.11111e+60 spmb=1.11111e+15 spomb=0 spomb1=1.11111e+60
B0_SP1p (B0_h1p B0_kb1 B0_fp bankvdd) pmos_lvt l=30n w=2u multi=1 nf=1 sd=100n ad=1.5e-13 as=1.5e-13 pd=4.15u ps=4.15u nrd=0.082877 nrs=0.082877 sa=75.0n sb=75.0n sa1=75.0n sa2=75.0n sa3=75.0n sa4=75.0n sb1=75.0n sb2=75.0n sb3=75.0n spa=100n spa1=100n spa2=100n spa3=100n sap=91.9776n sapb=114.444n spba=115.715n spba1=117.043n dfm_flag=0 _ccoflag=1 _rcoflag=1 _rgflag=1 spmt=1.11111e+15 spomt=0 spomt1=1.11111e+60 spmb=1.11111e+15 spomb=0 spomb1=1.11111e+60
B0_CH1p (B0_h1p 0) capacitor c=2.5e-14
B0_RH1p (B0_h1p B0_fp) resistor r=1T
B0_SN2p (B0_h2p B0_ck2 B0_fp 0) nmos_lvt l=30n w=2u multi=1 nf=1 sd=100n ad=1.5e-13 as=1.5e-13 pd=4.15u ps=4.15u nrd=0.144730 nrs=0.144730 sa=75.0n sb=75.0n sa1=75.0n sa2=75.0n sa3=75.0n sa4=75.0n sb1=75.0n sb2=75.0n sb3=75.0n spa=100n spa1=100n spa2=100n spa3=100n sap=91.9776n sapb=114.444n spba=115.715n spba1=117.043n dfm_flag=0 _ccoflag=1 _rcoflag=1 _rgflag=1 spmt=1.11111e+15 spomt=0 spomt1=1.11111e+60 spmb=1.11111e+15 spomb=0 spomb1=1.11111e+60
B0_SP2p (B0_h2p B0_kb2 B0_fp bankvdd) pmos_lvt l=30n w=2u multi=1 nf=1 sd=100n ad=1.5e-13 as=1.5e-13 pd=4.15u ps=4.15u nrd=0.082877 nrs=0.082877 sa=75.0n sb=75.0n sa1=75.0n sa2=75.0n sa3=75.0n sa4=75.0n sb1=75.0n sb2=75.0n sb3=75.0n spa=100n spa1=100n spa2=100n spa3=100n sap=91.9776n sapb=114.444n spba=115.715n spba1=117.043n dfm_flag=0 _ccoflag=1 _rcoflag=1 _rgflag=1 spmt=1.11111e+15 spomt=0 spomt1=1.11111e+60 spmb=1.11111e+15 spomb=0 spomb1=1.11111e+60
B0_CH2p (B0_h2p 0) capacitor c=2.5e-14
B0_RH2p (B0_h2p B0_fp) resistor r=1T
B0_SN3p (B0_h3p B0_ck3 B0_fp 0) nmos_lvt l=30n w=2u multi=1 nf=1 sd=100n ad=1.5e-13 as=1.5e-13 pd=4.15u ps=4.15u nrd=0.144730 nrs=0.144730 sa=75.0n sb=75.0n sa1=75.0n sa2=75.0n sa3=75.0n sa4=75.0n sb1=75.0n sb2=75.0n sb3=75.0n spa=100n spa1=100n spa2=100n spa3=100n sap=91.9776n sapb=114.444n spba=115.715n spba1=117.043n dfm_flag=0 _ccoflag=1 _rcoflag=1 _rgflag=1 spmt=1.11111e+15 spomt=0 spomt1=1.11111e+60 spmb=1.11111e+15 spomb=0 spomb1=1.11111e+60
B0_SP3p (B0_h3p B0_kb3 B0_fp bankvdd) pmos_lvt l=30n w=2u multi=1 nf=1 sd=100n ad=1.5e-13 as=1.5e-13 pd=4.15u ps=4.15u nrd=0.082877 nrs=0.082877 sa=75.0n sb=75.0n sa1=75.0n sa2=75.0n sa3=75.0n sa4=75.0n sb1=75.0n sb2=75.0n sb3=75.0n spa=100n spa1=100n spa2=100n spa3=100n sap=91.9776n sapb=114.444n spba=115.715n spba1=117.043n dfm_flag=0 _ccoflag=1 _rcoflag=1 _rgflag=1 spmt=1.11111e+15 spomt=0 spomt1=1.11111e+60 spmb=1.11111e+15 spomb=0 spomb1=1.11111e+60
B0_CH3p (B0_h3p 0) capacitor c=2.5e-14
B0_RH3p (B0_h3p B0_fp) resistor r=1T
B0_SN4p (B0_h4p B0_ck4 B0_fp 0) nmos_lvt l=30n w=2u multi=1 nf=1 sd=100n ad=1.5e-13 as=1.5e-13 pd=4.15u ps=4.15u nrd=0.144730 nrs=0.144730 sa=75.0n sb=75.0n sa1=75.0n sa2=75.0n sa3=75.0n sa4=75.0n sb1=75.0n sb2=75.0n sb3=75.0n spa=100n spa1=100n spa2=100n spa3=100n sap=91.9776n sapb=114.444n spba=115.715n spba1=117.043n dfm_flag=0 _ccoflag=1 _rcoflag=1 _rgflag=1 spmt=1.11111e+15 spomt=0 spomt1=1.11111e+60 spmb=1.11111e+15 spomb=0 spomb1=1.11111e+60
B0_SP4p (B0_h4p B0_kb4 B0_fp bankvdd) pmos_lvt l=30n w=2u multi=1 nf=1 sd=100n ad=1.5e-13 as=1.5e-13 pd=4.15u ps=4.15u nrd=0.082877 nrs=0.082877 sa=75.0n sb=75.0n sa1=75.0n sa2=75.0n sa3=75.0n sa4=75.0n sb1=75.0n sb2=75.0n sb3=75.0n spa=100n spa1=100n spa2=100n spa3=100n sap=91.9776n sapb=114.444n spba=115.715n spba1=117.043n dfm_flag=0 _ccoflag=1 _rcoflag=1 _rgflag=1 spmt=1.11111e+15 spomt=0 spomt1=1.11111e+60 spmb=1.11111e+15 spomb=0 spomb1=1.11111e+60
B0_CH4p (B0_h4p 0) capacitor c=2.5e-14
B0_RH4p (B0_h4p B0_fp) resistor r=1T
B0_SN5p (B0_h5p B0_ck5 B0_fp 0) nmos_lvt l=30n w=2u multi=1 nf=1 sd=100n ad=1.5e-13 as=1.5e-13 pd=4.15u ps=4.15u nrd=0.144730 nrs=0.144730 sa=75.0n sb=75.0n sa1=75.0n sa2=75.0n sa3=75.0n sa4=75.0n sb1=75.0n sb2=75.0n sb3=75.0n spa=100n spa1=100n spa2=100n spa3=100n sap=91.9776n sapb=114.444n spba=115.715n spba1=117.043n dfm_flag=0 _ccoflag=1 _rcoflag=1 _rgflag=1 spmt=1.11111e+15 spomt=0 spomt1=1.11111e+60 spmb=1.11111e+15 spomb=0 spomb1=1.11111e+60
B0_SP5p (B0_h5p B0_kb5 B0_fp bankvdd) pmos_lvt l=30n w=2u multi=1 nf=1 sd=100n ad=1.5e-13 as=1.5e-13 pd=4.15u ps=4.15u nrd=0.082877 nrs=0.082877 sa=75.0n sb=75.0n sa1=75.0n sa2=75.0n sa3=75.0n sa4=75.0n sb1=75.0n sb2=75.0n sb3=75.0n spa=100n spa1=100n spa2=100n spa3=100n sap=91.9776n sapb=114.444n spba=115.715n spba1=117.043n dfm_flag=0 _ccoflag=1 _rcoflag=1 _rgflag=1 spmt=1.11111e+15 spomt=0 spomt1=1.11111e+60 spmb=1.11111e+15 spomb=0 spomb1=1.11111e+60
B0_CH5p (B0_h5p 0) capacitor c=2.5e-14
B0_RH5p (B0_h5p B0_fp) resistor r=1T
B0_SN6p (B0_h6p B0_ck6 B0_fp 0) nmos_lvt l=30n w=2u multi=1 nf=1 sd=100n ad=1.5e-13 as=1.5e-13 pd=4.15u ps=4.15u nrd=0.144730 nrs=0.144730 sa=75.0n sb=75.0n sa1=75.0n sa2=75.0n sa3=75.0n sa4=75.0n sb1=75.0n sb2=75.0n sb3=75.0n spa=100n spa1=100n spa2=100n spa3=100n sap=91.9776n sapb=114.444n spba=115.715n spba1=117.043n dfm_flag=0 _ccoflag=1 _rcoflag=1 _rgflag=1 spmt=1.11111e+15 spomt=0 spomt1=1.11111e+60 spmb=1.11111e+15 spomb=0 spomb1=1.11111e+60
B0_SP6p (B0_h6p B0_kb6 B0_fp bankvdd) pmos_lvt l=30n w=2u multi=1 nf=1 sd=100n ad=1.5e-13 as=1.5e-13 pd=4.15u ps=4.15u nrd=0.082877 nrs=0.082877 sa=75.0n sb=75.0n sa1=75.0n sa2=75.0n sa3=75.0n sa4=75.0n sb1=75.0n sb2=75.0n sb3=75.0n spa=100n spa1=100n spa2=100n spa3=100n sap=91.9776n sapb=114.444n spba=115.715n spba1=117.043n dfm_flag=0 _ccoflag=1 _rcoflag=1 _rgflag=1 spmt=1.11111e+15 spomt=0 spomt1=1.11111e+60 spmb=1.11111e+15 spomb=0 spomb1=1.11111e+60
B0_CH6p (B0_h6p 0) capacitor c=2.5e-14
B0_RH6p (B0_h6p B0_fp) resistor r=1T
B0_SN7p (B0_h7p B0_ck7 B0_fp 0) nmos_lvt l=30n w=2u multi=1 nf=1 sd=100n ad=1.5e-13 as=1.5e-13 pd=4.15u ps=4.15u nrd=0.144730 nrs=0.144730 sa=75.0n sb=75.0n sa1=75.0n sa2=75.0n sa3=75.0n sa4=75.0n sb1=75.0n sb2=75.0n sb3=75.0n spa=100n spa1=100n spa2=100n spa3=100n sap=91.9776n sapb=114.444n spba=115.715n spba1=117.043n dfm_flag=0 _ccoflag=1 _rcoflag=1 _rgflag=1 spmt=1.11111e+15 spomt=0 spomt1=1.11111e+60 spmb=1.11111e+15 spomb=0 spomb1=1.11111e+60
B0_SP7p (B0_h7p B0_kb7 B0_fp bankvdd) pmos_lvt l=30n w=2u multi=1 nf=1 sd=100n ad=1.5e-13 as=1.5e-13 pd=4.15u ps=4.15u nrd=0.082877 nrs=0.082877 sa=75.0n sb=75.0n sa1=75.0n sa2=75.0n sa3=75.0n sa4=75.0n sb1=75.0n sb2=75.0n sb3=75.0n spa=100n spa1=100n spa2=100n spa3=100n sap=91.9776n sapb=114.444n spba=115.715n spba1=117.043n dfm_flag=0 _ccoflag=1 _rcoflag=1 _rgflag=1 spmt=1.11111e+15 spomt=0 spomt1=1.11111e+60 spmb=1.11111e+15 spomb=0 spomb1=1.11111e+60
B0_CH7p (B0_h7p 0) capacitor c=2.5e-14
B0_RH7p (B0_h7p B0_fp) resistor r=1T
RB0_Lm (bankvdd B0_fm) resistor r=500
B0_Fm (B0_fm X_h0m B0_em 0) nmos_lvt l=30n w=2u multi=1 nf=1 sd=100n ad=1.5e-13 as=1.5e-13 pd=4.15u ps=4.15u nrd=0.144730 nrs=0.144730 sa=75.0n sb=75.0n sa1=75.0n sa2=75.0n sa3=75.0n sa4=75.0n sb1=75.0n sb2=75.0n sb3=75.0n spa=100n spa1=100n spa2=100n spa3=100n sap=91.9776n sapb=114.444n spba=115.715n spba1=117.043n dfm_flag=0 _ccoflag=1 _rcoflag=1 _rgflag=1 spmt=1.11111e+15 spomt=0 spomt1=1.11111e+60 spmb=1.11111e+15 spomb=0 spomb1=1.11111e+60
B0_Tm (B0_em nbias 0 0) nmos_lvt l=60n w=2u multi=1 nf=1 sd=100n ad=1.5e-13 as=1.5e-13 pd=4.15u ps=4.15u nrd=0.144730 nrs=0.144730 sa=75.0n sb=75.0n sa1=75.0n sa2=75.0n sa3=75.0n sa4=75.0n sb1=75.0n sb2=75.0n sb3=75.0n spa=100n spa1=100n spa2=100n spa3=100n sap=91.9776n sapb=120.93n spba=121.82n spba1=124.403n dfm_flag=0 _ccoflag=1 _rcoflag=1 _rgflag=1 spmt=1.11111e+15 spomt=0 spomt1=1.11111e+60 spmb=1.11111e+15 spomb=0 spomb1=1.11111e+60
B0_SN0m (B0_h0m B0_ck0 B0_fm 0) nmos_lvt l=30n w=2u multi=1 nf=1 sd=100n ad=1.5e-13 as=1.5e-13 pd=4.15u ps=4.15u nrd=0.144730 nrs=0.144730 sa=75.0n sb=75.0n sa1=75.0n sa2=75.0n sa3=75.0n sa4=75.0n sb1=75.0n sb2=75.0n sb3=75.0n spa=100n spa1=100n spa2=100n spa3=100n sap=91.9776n sapb=114.444n spba=115.715n spba1=117.043n dfm_flag=0 _ccoflag=1 _rcoflag=1 _rgflag=1 spmt=1.11111e+15 spomt=0 spomt1=1.11111e+60 spmb=1.11111e+15 spomb=0 spomb1=1.11111e+60
B0_SP0m (B0_h0m B0_kb0 B0_fm bankvdd) pmos_lvt l=30n w=2u multi=1 nf=1 sd=100n ad=1.5e-13 as=1.5e-13 pd=4.15u ps=4.15u nrd=0.082877 nrs=0.082877 sa=75.0n sb=75.0n sa1=75.0n sa2=75.0n sa3=75.0n sa4=75.0n sb1=75.0n sb2=75.0n sb3=75.0n spa=100n spa1=100n spa2=100n spa3=100n sap=91.9776n sapb=114.444n spba=115.715n spba1=117.043n dfm_flag=0 _ccoflag=1 _rcoflag=1 _rgflag=1 spmt=1.11111e+15 spomt=0 spomt1=1.11111e+60 spmb=1.11111e+15 spomb=0 spomb1=1.11111e+60
B0_CH0m (B0_h0m 0) capacitor c=2.5e-14
B0_RH0m (B0_h0m B0_fm) resistor r=1T
B0_SN1m (B0_h1m B0_ck1 B0_fm 0) nmos_lvt l=30n w=2u multi=1 nf=1 sd=100n ad=1.5e-13 as=1.5e-13 pd=4.15u ps=4.15u nrd=0.144730 nrs=0.144730 sa=75.0n sb=75.0n sa1=75.0n sa2=75.0n sa3=75.0n sa4=75.0n sb1=75.0n sb2=75.0n sb3=75.0n spa=100n spa1=100n spa2=100n spa3=100n sap=91.9776n sapb=114.444n spba=115.715n spba1=117.043n dfm_flag=0 _ccoflag=1 _rcoflag=1 _rgflag=1 spmt=1.11111e+15 spomt=0 spomt1=1.11111e+60 spmb=1.11111e+15 spomb=0 spomb1=1.11111e+60
B0_SP1m (B0_h1m B0_kb1 B0_fm bankvdd) pmos_lvt l=30n w=2u multi=1 nf=1 sd=100n ad=1.5e-13 as=1.5e-13 pd=4.15u ps=4.15u nrd=0.082877 nrs=0.082877 sa=75.0n sb=75.0n sa1=75.0n sa2=75.0n sa3=75.0n sa4=75.0n sb1=75.0n sb2=75.0n sb3=75.0n spa=100n spa1=100n spa2=100n spa3=100n sap=91.9776n sapb=114.444n spba=115.715n spba1=117.043n dfm_flag=0 _ccoflag=1 _rcoflag=1 _rgflag=1 spmt=1.11111e+15 spomt=0 spomt1=1.11111e+60 spmb=1.11111e+15 spomb=0 spomb1=1.11111e+60
B0_CH1m (B0_h1m 0) capacitor c=2.5e-14
B0_RH1m (B0_h1m B0_fm) resistor r=1T
B0_SN2m (B0_h2m B0_ck2 B0_fm 0) nmos_lvt l=30n w=2u multi=1 nf=1 sd=100n ad=1.5e-13 as=1.5e-13 pd=4.15u ps=4.15u nrd=0.144730 nrs=0.144730 sa=75.0n sb=75.0n sa1=75.0n sa2=75.0n sa3=75.0n sa4=75.0n sb1=75.0n sb2=75.0n sb3=75.0n spa=100n spa1=100n spa2=100n spa3=100n sap=91.9776n sapb=114.444n spba=115.715n spba1=117.043n dfm_flag=0 _ccoflag=1 _rcoflag=1 _rgflag=1 spmt=1.11111e+15 spomt=0 spomt1=1.11111e+60 spmb=1.11111e+15 spomb=0 spomb1=1.11111e+60
B0_SP2m (B0_h2m B0_kb2 B0_fm bankvdd) pmos_lvt l=30n w=2u multi=1 nf=1 sd=100n ad=1.5e-13 as=1.5e-13 pd=4.15u ps=4.15u nrd=0.082877 nrs=0.082877 sa=75.0n sb=75.0n sa1=75.0n sa2=75.0n sa3=75.0n sa4=75.0n sb1=75.0n sb2=75.0n sb3=75.0n spa=100n spa1=100n spa2=100n spa3=100n sap=91.9776n sapb=114.444n spba=115.715n spba1=117.043n dfm_flag=0 _ccoflag=1 _rcoflag=1 _rgflag=1 spmt=1.11111e+15 spomt=0 spomt1=1.11111e+60 spmb=1.11111e+15 spomb=0 spomb1=1.11111e+60
B0_CH2m (B0_h2m 0) capacitor c=2.5e-14
B0_RH2m (B0_h2m B0_fm) resistor r=1T
B0_SN3m (B0_h3m B0_ck3 B0_fm 0) nmos_lvt l=30n w=2u multi=1 nf=1 sd=100n ad=1.5e-13 as=1.5e-13 pd=4.15u ps=4.15u nrd=0.144730 nrs=0.144730 sa=75.0n sb=75.0n sa1=75.0n sa2=75.0n sa3=75.0n sa4=75.0n sb1=75.0n sb2=75.0n sb3=75.0n spa=100n spa1=100n spa2=100n spa3=100n sap=91.9776n sapb=114.444n spba=115.715n spba1=117.043n dfm_flag=0 _ccoflag=1 _rcoflag=1 _rgflag=1 spmt=1.11111e+15 spomt=0 spomt1=1.11111e+60 spmb=1.11111e+15 spomb=0 spomb1=1.11111e+60
B0_SP3m (B0_h3m B0_kb3 B0_fm bankvdd) pmos_lvt l=30n w=2u multi=1 nf=1 sd=100n ad=1.5e-13 as=1.5e-13 pd=4.15u ps=4.15u nrd=0.082877 nrs=0.082877 sa=75.0n sb=75.0n sa1=75.0n sa2=75.0n sa3=75.0n sa4=75.0n sb1=75.0n sb2=75.0n sb3=75.0n spa=100n spa1=100n spa2=100n spa3=100n sap=91.9776n sapb=114.444n spba=115.715n spba1=117.043n dfm_flag=0 _ccoflag=1 _rcoflag=1 _rgflag=1 spmt=1.11111e+15 spomt=0 spomt1=1.11111e+60 spmb=1.11111e+15 spomb=0 spomb1=1.11111e+60
B0_CH3m (B0_h3m 0) capacitor c=2.5e-14
B0_RH3m (B0_h3m B0_fm) resistor r=1T
B0_SN4m (B0_h4m B0_ck4 B0_fm 0) nmos_lvt l=30n w=2u multi=1 nf=1 sd=100n ad=1.5e-13 as=1.5e-13 pd=4.15u ps=4.15u nrd=0.144730 nrs=0.144730 sa=75.0n sb=75.0n sa1=75.0n sa2=75.0n sa3=75.0n sa4=75.0n sb1=75.0n sb2=75.0n sb3=75.0n spa=100n spa1=100n spa2=100n spa3=100n sap=91.9776n sapb=114.444n spba=115.715n spba1=117.043n dfm_flag=0 _ccoflag=1 _rcoflag=1 _rgflag=1 spmt=1.11111e+15 spomt=0 spomt1=1.11111e+60 spmb=1.11111e+15 spomb=0 spomb1=1.11111e+60
B0_SP4m (B0_h4m B0_kb4 B0_fm bankvdd) pmos_lvt l=30n w=2u multi=1 nf=1 sd=100n ad=1.5e-13 as=1.5e-13 pd=4.15u ps=4.15u nrd=0.082877 nrs=0.082877 sa=75.0n sb=75.0n sa1=75.0n sa2=75.0n sa3=75.0n sa4=75.0n sb1=75.0n sb2=75.0n sb3=75.0n spa=100n spa1=100n spa2=100n spa3=100n sap=91.9776n sapb=114.444n spba=115.715n spba1=117.043n dfm_flag=0 _ccoflag=1 _rcoflag=1 _rgflag=1 spmt=1.11111e+15 spomt=0 spomt1=1.11111e+60 spmb=1.11111e+15 spomb=0 spomb1=1.11111e+60
B0_CH4m (B0_h4m 0) capacitor c=2.5e-14
B0_RH4m (B0_h4m B0_fm) resistor r=1T
B0_SN5m (B0_h5m B0_ck5 B0_fm 0) nmos_lvt l=30n w=2u multi=1 nf=1 sd=100n ad=1.5e-13 as=1.5e-13 pd=4.15u ps=4.15u nrd=0.144730 nrs=0.144730 sa=75.0n sb=75.0n sa1=75.0n sa2=75.0n sa3=75.0n sa4=75.0n sb1=75.0n sb2=75.0n sb3=75.0n spa=100n spa1=100n spa2=100n spa3=100n sap=91.9776n sapb=114.444n spba=115.715n spba1=117.043n dfm_flag=0 _ccoflag=1 _rcoflag=1 _rgflag=1 spmt=1.11111e+15 spomt=0 spomt1=1.11111e+60 spmb=1.11111e+15 spomb=0 spomb1=1.11111e+60
B0_SP5m (B0_h5m B0_kb5 B0_fm bankvdd) pmos_lvt l=30n w=2u multi=1 nf=1 sd=100n ad=1.5e-13 as=1.5e-13 pd=4.15u ps=4.15u nrd=0.082877 nrs=0.082877 sa=75.0n sb=75.0n sa1=75.0n sa2=75.0n sa3=75.0n sa4=75.0n sb1=75.0n sb2=75.0n sb3=75.0n spa=100n spa1=100n spa2=100n spa3=100n sap=91.9776n sapb=114.444n spba=115.715n spba1=117.043n dfm_flag=0 _ccoflag=1 _rcoflag=1 _rgflag=1 spmt=1.11111e+15 spomt=0 spomt1=1.11111e+60 spmb=1.11111e+15 spomb=0 spomb1=1.11111e+60
B0_CH5m (B0_h5m 0) capacitor c=2.5e-14
B0_RH5m (B0_h5m B0_fm) resistor r=1T
B0_SN6m (B0_h6m B0_ck6 B0_fm 0) nmos_lvt l=30n w=2u multi=1 nf=1 sd=100n ad=1.5e-13 as=1.5e-13 pd=4.15u ps=4.15u nrd=0.144730 nrs=0.144730 sa=75.0n sb=75.0n sa1=75.0n sa2=75.0n sa3=75.0n sa4=75.0n sb1=75.0n sb2=75.0n sb3=75.0n spa=100n spa1=100n spa2=100n spa3=100n sap=91.9776n sapb=114.444n spba=115.715n spba1=117.043n dfm_flag=0 _ccoflag=1 _rcoflag=1 _rgflag=1 spmt=1.11111e+15 spomt=0 spomt1=1.11111e+60 spmb=1.11111e+15 spomb=0 spomb1=1.11111e+60
B0_SP6m (B0_h6m B0_kb6 B0_fm bankvdd) pmos_lvt l=30n w=2u multi=1 nf=1 sd=100n ad=1.5e-13 as=1.5e-13 pd=4.15u ps=4.15u nrd=0.082877 nrs=0.082877 sa=75.0n sb=75.0n sa1=75.0n sa2=75.0n sa3=75.0n sa4=75.0n sb1=75.0n sb2=75.0n sb3=75.0n spa=100n spa1=100n spa2=100n spa3=100n sap=91.9776n sapb=114.444n spba=115.715n spba1=117.043n dfm_flag=0 _ccoflag=1 _rcoflag=1 _rgflag=1 spmt=1.11111e+15 spomt=0 spomt1=1.11111e+60 spmb=1.11111e+15 spomb=0 spomb1=1.11111e+60
B0_CH6m (B0_h6m 0) capacitor c=2.5e-14
B0_RH6m (B0_h6m B0_fm) resistor r=1T
B0_SN7m (B0_h7m B0_ck7 B0_fm 0) nmos_lvt l=30n w=2u multi=1 nf=1 sd=100n ad=1.5e-13 as=1.5e-13 pd=4.15u ps=4.15u nrd=0.144730 nrs=0.144730 sa=75.0n sb=75.0n sa1=75.0n sa2=75.0n sa3=75.0n sa4=75.0n sb1=75.0n sb2=75.0n sb3=75.0n spa=100n spa1=100n spa2=100n spa3=100n sap=91.9776n sapb=114.444n spba=115.715n spba1=117.043n dfm_flag=0 _ccoflag=1 _rcoflag=1 _rgflag=1 spmt=1.11111e+15 spomt=0 spomt1=1.11111e+60 spmb=1.11111e+15 spomb=0 spomb1=1.11111e+60
B0_SP7m (B0_h7m B0_kb7 B0_fm bankvdd) pmos_lvt l=30n w=2u multi=1 nf=1 sd=100n ad=1.5e-13 as=1.5e-13 pd=4.15u ps=4.15u nrd=0.082877 nrs=0.082877 sa=75.0n sb=75.0n sa1=75.0n sa2=75.0n sa3=75.0n sa4=75.0n sb1=75.0n sb2=75.0n sb3=75.0n spa=100n spa1=100n spa2=100n spa3=100n sap=91.9776n sapb=114.444n spba=115.715n spba1=117.043n dfm_flag=0 _ccoflag=1 _rcoflag=1 _rgflag=1 spmt=1.11111e+15 spomt=0 spomt1=1.11111e+60 spmb=1.11111e+15 spomb=0 spomb1=1.11111e+60
B0_CH7m (B0_h7m 0) capacitor c=2.5e-14
B0_RH7m (B0_h7m B0_fm) resistor r=1T
B0_RDEG (B0_ep B0_em) resistor r=250
B0_COMP0 (B0_h0p B0_h0m compvdd logicvdd) COMPLOAD
B0_COMP1 (B0_h1p B0_h1m compvdd logicvdd) COMPLOAD
B0_COMP2 (B0_h2p B0_h2m compvdd logicvdd) COMPLOAD
B0_COMP3 (B0_h3p B0_h3m compvdd logicvdd) COMPLOAD
B0_COMP4 (B0_h4p B0_h4m compvdd logicvdd) COMPLOAD
B0_COMP5 (B0_h5p B0_h5m compvdd logicvdd) COMPLOAD
B0_COMP6 (B0_h6p B0_h6m compvdd logicvdd) COMPLOAD
B0_COMP7 (B0_h7p B0_h7m compvdd logicvdd) COMPLOAD
B1_ck0V (B1_ck0 0) vsource type=pulse val0=0 val1=0.9 delay=1.131611428571429e-10 rise=1e-12 fall=1e-12 width=6.471430000000002e-11 period=5.714288e-10
B1_kb0V (B1_kb0 0) vsource type=pulse val0=0.9 val1=0 delay=1.131611428571429e-10 rise=1e-12 fall=1e-12 width=6.471430000000002e-11 period=5.714288e-10
B1_ck1V (B1_ck1 0) vsource type=pulse val0=0 val1=0.9 delay=1.845897428571429e-10 rise=1e-12 fall=1e-12 width=6.471430000000002e-11 period=5.714288e-10
B1_kb1V (B1_kb1 0) vsource type=pulse val0=0.9 val1=0 delay=1.845897428571429e-10 rise=1e-12 fall=1e-12 width=6.471430000000002e-11 period=5.714288e-10
B1_ck2V (B1_ck2 0) vsource type=pulse val0=0 val1=0.9 delay=2.560183428571429e-10 rise=1e-12 fall=1e-12 width=6.471430000000002e-11 period=5.714288e-10
B1_kb2V (B1_kb2 0) vsource type=pulse val0=0.9 val1=0 delay=2.560183428571429e-10 rise=1e-12 fall=1e-12 width=6.471430000000002e-11 period=5.714288e-10
B1_ck3V (B1_ck3 0) vsource type=pulse val0=0 val1=0.9 delay=3.274469428571429e-10 rise=1e-12 fall=1e-12 width=6.471430000000002e-11 period=5.714288e-10
B1_kb3V (B1_kb3 0) vsource type=pulse val0=0.9 val1=0 delay=3.274469428571429e-10 rise=1e-12 fall=1e-12 width=6.471430000000002e-11 period=5.714288e-10
B1_ck4V (B1_ck4 0) vsource type=pulse val0=0 val1=0.9 delay=3.988755428571429e-10 rise=1e-12 fall=1e-12 width=6.471430000000002e-11 period=5.714288e-10
B1_kb4V (B1_kb4 0) vsource type=pulse val0=0.9 val1=0 delay=3.988755428571429e-10 rise=1e-12 fall=1e-12 width=6.471430000000002e-11 period=5.714288e-10
B1_ck5V (B1_ck5 0) vsource type=pulse val0=0 val1=0.9 delay=4.703041428571428e-10 rise=1e-12 fall=1e-12 width=6.471430000000002e-11 period=5.714288e-10
B1_kb5V (B1_kb5 0) vsource type=pulse val0=0.9 val1=0 delay=4.703041428571428e-10 rise=1e-12 fall=1e-12 width=6.471430000000002e-11 period=5.714288e-10
B1_ck6V (B1_ck6 0) vsource type=pulse val0=0 val1=0.9 delay=5.417327428571428e-10 rise=1e-12 fall=1e-12 width=6.471430000000002e-11 period=5.714288e-10
B1_kb6V (B1_kb6 0) vsource type=pulse val0=0.9 val1=0 delay=5.417327428571428e-10 rise=1e-12 fall=1e-12 width=6.471430000000002e-11 period=5.714288e-10
B1_ck7V (B1_ck7 0) vsource type=pulse val0=0 val1=0.9 delay=6.131613428571428e-10 rise=1e-12 fall=1e-12 width=6.471430000000002e-11 period=5.714288e-10
B1_kb7V (B1_kb7 0) vsource type=pulse val0=0.9 val1=0 delay=6.131613428571428e-10 rise=1e-12 fall=1e-12 width=6.471430000000002e-11 period=5.714288e-10
RB1_Lp (bankvdd B1_fp) resistor r=500
B1_Fp (B1_fp X_h1p B1_ep 0) nmos_lvt l=30n w=2u multi=1 nf=1 sd=100n ad=1.5e-13 as=1.5e-13 pd=4.15u ps=4.15u nrd=0.144730 nrs=0.144730 sa=75.0n sb=75.0n sa1=75.0n sa2=75.0n sa3=75.0n sa4=75.0n sb1=75.0n sb2=75.0n sb3=75.0n spa=100n spa1=100n spa2=100n spa3=100n sap=91.9776n sapb=114.444n spba=115.715n spba1=117.043n dfm_flag=0 _ccoflag=1 _rcoflag=1 _rgflag=1 spmt=1.11111e+15 spomt=0 spomt1=1.11111e+60 spmb=1.11111e+15 spomb=0 spomb1=1.11111e+60
B1_Tp (B1_ep nbias 0 0) nmos_lvt l=60n w=2u multi=1 nf=1 sd=100n ad=1.5e-13 as=1.5e-13 pd=4.15u ps=4.15u nrd=0.144730 nrs=0.144730 sa=75.0n sb=75.0n sa1=75.0n sa2=75.0n sa3=75.0n sa4=75.0n sb1=75.0n sb2=75.0n sb3=75.0n spa=100n spa1=100n spa2=100n spa3=100n sap=91.9776n sapb=120.93n spba=121.82n spba1=124.403n dfm_flag=0 _ccoflag=1 _rcoflag=1 _rgflag=1 spmt=1.11111e+15 spomt=0 spomt1=1.11111e+60 spmb=1.11111e+15 spomb=0 spomb1=1.11111e+60
B1_SN0p (B1_h0p B1_ck0 B1_fp 0) nmos_lvt l=30n w=2u multi=1 nf=1 sd=100n ad=1.5e-13 as=1.5e-13 pd=4.15u ps=4.15u nrd=0.144730 nrs=0.144730 sa=75.0n sb=75.0n sa1=75.0n sa2=75.0n sa3=75.0n sa4=75.0n sb1=75.0n sb2=75.0n sb3=75.0n spa=100n spa1=100n spa2=100n spa3=100n sap=91.9776n sapb=114.444n spba=115.715n spba1=117.043n dfm_flag=0 _ccoflag=1 _rcoflag=1 _rgflag=1 spmt=1.11111e+15 spomt=0 spomt1=1.11111e+60 spmb=1.11111e+15 spomb=0 spomb1=1.11111e+60
B1_SP0p (B1_h0p B1_kb0 B1_fp bankvdd) pmos_lvt l=30n w=2u multi=1 nf=1 sd=100n ad=1.5e-13 as=1.5e-13 pd=4.15u ps=4.15u nrd=0.082877 nrs=0.082877 sa=75.0n sb=75.0n sa1=75.0n sa2=75.0n sa3=75.0n sa4=75.0n sb1=75.0n sb2=75.0n sb3=75.0n spa=100n spa1=100n spa2=100n spa3=100n sap=91.9776n sapb=114.444n spba=115.715n spba1=117.043n dfm_flag=0 _ccoflag=1 _rcoflag=1 _rgflag=1 spmt=1.11111e+15 spomt=0 spomt1=1.11111e+60 spmb=1.11111e+15 spomb=0 spomb1=1.11111e+60
B1_CH0p (B1_h0p 0) capacitor c=2.5e-14
B1_RH0p (B1_h0p B1_fp) resistor r=1T
B1_SN1p (B1_h1p B1_ck1 B1_fp 0) nmos_lvt l=30n w=2u multi=1 nf=1 sd=100n ad=1.5e-13 as=1.5e-13 pd=4.15u ps=4.15u nrd=0.144730 nrs=0.144730 sa=75.0n sb=75.0n sa1=75.0n sa2=75.0n sa3=75.0n sa4=75.0n sb1=75.0n sb2=75.0n sb3=75.0n spa=100n spa1=100n spa2=100n spa3=100n sap=91.9776n sapb=114.444n spba=115.715n spba1=117.043n dfm_flag=0 _ccoflag=1 _rcoflag=1 _rgflag=1 spmt=1.11111e+15 spomt=0 spomt1=1.11111e+60 spmb=1.11111e+15 spomb=0 spomb1=1.11111e+60
B1_SP1p (B1_h1p B1_kb1 B1_fp bankvdd) pmos_lvt l=30n w=2u multi=1 nf=1 sd=100n ad=1.5e-13 as=1.5e-13 pd=4.15u ps=4.15u nrd=0.082877 nrs=0.082877 sa=75.0n sb=75.0n sa1=75.0n sa2=75.0n sa3=75.0n sa4=75.0n sb1=75.0n sb2=75.0n sb3=75.0n spa=100n spa1=100n spa2=100n spa3=100n sap=91.9776n sapb=114.444n spba=115.715n spba1=117.043n dfm_flag=0 _ccoflag=1 _rcoflag=1 _rgflag=1 spmt=1.11111e+15 spomt=0 spomt1=1.11111e+60 spmb=1.11111e+15 spomb=0 spomb1=1.11111e+60
B1_CH1p (B1_h1p 0) capacitor c=2.5e-14
B1_RH1p (B1_h1p B1_fp) resistor r=1T
B1_SN2p (B1_h2p B1_ck2 B1_fp 0) nmos_lvt l=30n w=2u multi=1 nf=1 sd=100n ad=1.5e-13 as=1.5e-13 pd=4.15u ps=4.15u nrd=0.144730 nrs=0.144730 sa=75.0n sb=75.0n sa1=75.0n sa2=75.0n sa3=75.0n sa4=75.0n sb1=75.0n sb2=75.0n sb3=75.0n spa=100n spa1=100n spa2=100n spa3=100n sap=91.9776n sapb=114.444n spba=115.715n spba1=117.043n dfm_flag=0 _ccoflag=1 _rcoflag=1 _rgflag=1 spmt=1.11111e+15 spomt=0 spomt1=1.11111e+60 spmb=1.11111e+15 spomb=0 spomb1=1.11111e+60
B1_SP2p (B1_h2p B1_kb2 B1_fp bankvdd) pmos_lvt l=30n w=2u multi=1 nf=1 sd=100n ad=1.5e-13 as=1.5e-13 pd=4.15u ps=4.15u nrd=0.082877 nrs=0.082877 sa=75.0n sb=75.0n sa1=75.0n sa2=75.0n sa3=75.0n sa4=75.0n sb1=75.0n sb2=75.0n sb3=75.0n spa=100n spa1=100n spa2=100n spa3=100n sap=91.9776n sapb=114.444n spba=115.715n spba1=117.043n dfm_flag=0 _ccoflag=1 _rcoflag=1 _rgflag=1 spmt=1.11111e+15 spomt=0 spomt1=1.11111e+60 spmb=1.11111e+15 spomb=0 spomb1=1.11111e+60
B1_CH2p (B1_h2p 0) capacitor c=2.5e-14
B1_RH2p (B1_h2p B1_fp) resistor r=1T
B1_SN3p (B1_h3p B1_ck3 B1_fp 0) nmos_lvt l=30n w=2u multi=1 nf=1 sd=100n ad=1.5e-13 as=1.5e-13 pd=4.15u ps=4.15u nrd=0.144730 nrs=0.144730 sa=75.0n sb=75.0n sa1=75.0n sa2=75.0n sa3=75.0n sa4=75.0n sb1=75.0n sb2=75.0n sb3=75.0n spa=100n spa1=100n spa2=100n spa3=100n sap=91.9776n sapb=114.444n spba=115.715n spba1=117.043n dfm_flag=0 _ccoflag=1 _rcoflag=1 _rgflag=1 spmt=1.11111e+15 spomt=0 spomt1=1.11111e+60 spmb=1.11111e+15 spomb=0 spomb1=1.11111e+60
B1_SP3p (B1_h3p B1_kb3 B1_fp bankvdd) pmos_lvt l=30n w=2u multi=1 nf=1 sd=100n ad=1.5e-13 as=1.5e-13 pd=4.15u ps=4.15u nrd=0.082877 nrs=0.082877 sa=75.0n sb=75.0n sa1=75.0n sa2=75.0n sa3=75.0n sa4=75.0n sb1=75.0n sb2=75.0n sb3=75.0n spa=100n spa1=100n spa2=100n spa3=100n sap=91.9776n sapb=114.444n spba=115.715n spba1=117.043n dfm_flag=0 _ccoflag=1 _rcoflag=1 _rgflag=1 spmt=1.11111e+15 spomt=0 spomt1=1.11111e+60 spmb=1.11111e+15 spomb=0 spomb1=1.11111e+60
B1_CH3p (B1_h3p 0) capacitor c=2.5e-14
B1_RH3p (B1_h3p B1_fp) resistor r=1T
B1_SN4p (B1_h4p B1_ck4 B1_fp 0) nmos_lvt l=30n w=2u multi=1 nf=1 sd=100n ad=1.5e-13 as=1.5e-13 pd=4.15u ps=4.15u nrd=0.144730 nrs=0.144730 sa=75.0n sb=75.0n sa1=75.0n sa2=75.0n sa3=75.0n sa4=75.0n sb1=75.0n sb2=75.0n sb3=75.0n spa=100n spa1=100n spa2=100n spa3=100n sap=91.9776n sapb=114.444n spba=115.715n spba1=117.043n dfm_flag=0 _ccoflag=1 _rcoflag=1 _rgflag=1 spmt=1.11111e+15 spomt=0 spomt1=1.11111e+60 spmb=1.11111e+15 spomb=0 spomb1=1.11111e+60
B1_SP4p (B1_h4p B1_kb4 B1_fp bankvdd) pmos_lvt l=30n w=2u multi=1 nf=1 sd=100n ad=1.5e-13 as=1.5e-13 pd=4.15u ps=4.15u nrd=0.082877 nrs=0.082877 sa=75.0n sb=75.0n sa1=75.0n sa2=75.0n sa3=75.0n sa4=75.0n sb1=75.0n sb2=75.0n sb3=75.0n spa=100n spa1=100n spa2=100n spa3=100n sap=91.9776n sapb=114.444n spba=115.715n spba1=117.043n dfm_flag=0 _ccoflag=1 _rcoflag=1 _rgflag=1 spmt=1.11111e+15 spomt=0 spomt1=1.11111e+60 spmb=1.11111e+15 spomb=0 spomb1=1.11111e+60
B1_CH4p (B1_h4p 0) capacitor c=2.5e-14
B1_RH4p (B1_h4p B1_fp) resistor r=1T
B1_SN5p (B1_h5p B1_ck5 B1_fp 0) nmos_lvt l=30n w=2u multi=1 nf=1 sd=100n ad=1.5e-13 as=1.5e-13 pd=4.15u ps=4.15u nrd=0.144730 nrs=0.144730 sa=75.0n sb=75.0n sa1=75.0n sa2=75.0n sa3=75.0n sa4=75.0n sb1=75.0n sb2=75.0n sb3=75.0n spa=100n spa1=100n spa2=100n spa3=100n sap=91.9776n sapb=114.444n spba=115.715n spba1=117.043n dfm_flag=0 _ccoflag=1 _rcoflag=1 _rgflag=1 spmt=1.11111e+15 spomt=0 spomt1=1.11111e+60 spmb=1.11111e+15 spomb=0 spomb1=1.11111e+60
B1_SP5p (B1_h5p B1_kb5 B1_fp bankvdd) pmos_lvt l=30n w=2u multi=1 nf=1 sd=100n ad=1.5e-13 as=1.5e-13 pd=4.15u ps=4.15u nrd=0.082877 nrs=0.082877 sa=75.0n sb=75.0n sa1=75.0n sa2=75.0n sa3=75.0n sa4=75.0n sb1=75.0n sb2=75.0n sb3=75.0n spa=100n spa1=100n spa2=100n spa3=100n sap=91.9776n sapb=114.444n spba=115.715n spba1=117.043n dfm_flag=0 _ccoflag=1 _rcoflag=1 _rgflag=1 spmt=1.11111e+15 spomt=0 spomt1=1.11111e+60 spmb=1.11111e+15 spomb=0 spomb1=1.11111e+60
B1_CH5p (B1_h5p 0) capacitor c=2.5e-14
B1_RH5p (B1_h5p B1_fp) resistor r=1T
B1_SN6p (B1_h6p B1_ck6 B1_fp 0) nmos_lvt l=30n w=2u multi=1 nf=1 sd=100n ad=1.5e-13 as=1.5e-13 pd=4.15u ps=4.15u nrd=0.144730 nrs=0.144730 sa=75.0n sb=75.0n sa1=75.0n sa2=75.0n sa3=75.0n sa4=75.0n sb1=75.0n sb2=75.0n sb3=75.0n spa=100n spa1=100n spa2=100n spa3=100n sap=91.9776n sapb=114.444n spba=115.715n spba1=117.043n dfm_flag=0 _ccoflag=1 _rcoflag=1 _rgflag=1 spmt=1.11111e+15 spomt=0 spomt1=1.11111e+60 spmb=1.11111e+15 spomb=0 spomb1=1.11111e+60
B1_SP6p (B1_h6p B1_kb6 B1_fp bankvdd) pmos_lvt l=30n w=2u multi=1 nf=1 sd=100n ad=1.5e-13 as=1.5e-13 pd=4.15u ps=4.15u nrd=0.082877 nrs=0.082877 sa=75.0n sb=75.0n sa1=75.0n sa2=75.0n sa3=75.0n sa4=75.0n sb1=75.0n sb2=75.0n sb3=75.0n spa=100n spa1=100n spa2=100n spa3=100n sap=91.9776n sapb=114.444n spba=115.715n spba1=117.043n dfm_flag=0 _ccoflag=1 _rcoflag=1 _rgflag=1 spmt=1.11111e+15 spomt=0 spomt1=1.11111e+60 spmb=1.11111e+15 spomb=0 spomb1=1.11111e+60
B1_CH6p (B1_h6p 0) capacitor c=2.5e-14
B1_RH6p (B1_h6p B1_fp) resistor r=1T
B1_SN7p (B1_h7p B1_ck7 B1_fp 0) nmos_lvt l=30n w=2u multi=1 nf=1 sd=100n ad=1.5e-13 as=1.5e-13 pd=4.15u ps=4.15u nrd=0.144730 nrs=0.144730 sa=75.0n sb=75.0n sa1=75.0n sa2=75.0n sa3=75.0n sa4=75.0n sb1=75.0n sb2=75.0n sb3=75.0n spa=100n spa1=100n spa2=100n spa3=100n sap=91.9776n sapb=114.444n spba=115.715n spba1=117.043n dfm_flag=0 _ccoflag=1 _rcoflag=1 _rgflag=1 spmt=1.11111e+15 spomt=0 spomt1=1.11111e+60 spmb=1.11111e+15 spomb=0 spomb1=1.11111e+60
B1_SP7p (B1_h7p B1_kb7 B1_fp bankvdd) pmos_lvt l=30n w=2u multi=1 nf=1 sd=100n ad=1.5e-13 as=1.5e-13 pd=4.15u ps=4.15u nrd=0.082877 nrs=0.082877 sa=75.0n sb=75.0n sa1=75.0n sa2=75.0n sa3=75.0n sa4=75.0n sb1=75.0n sb2=75.0n sb3=75.0n spa=100n spa1=100n spa2=100n spa3=100n sap=91.9776n sapb=114.444n spba=115.715n spba1=117.043n dfm_flag=0 _ccoflag=1 _rcoflag=1 _rgflag=1 spmt=1.11111e+15 spomt=0 spomt1=1.11111e+60 spmb=1.11111e+15 spomb=0 spomb1=1.11111e+60
B1_CH7p (B1_h7p 0) capacitor c=2.5e-14
B1_RH7p (B1_h7p B1_fp) resistor r=1T
RB1_Lm (bankvdd B1_fm) resistor r=500
B1_Fm (B1_fm X_h1m B1_em 0) nmos_lvt l=30n w=2u multi=1 nf=1 sd=100n ad=1.5e-13 as=1.5e-13 pd=4.15u ps=4.15u nrd=0.144730 nrs=0.144730 sa=75.0n sb=75.0n sa1=75.0n sa2=75.0n sa3=75.0n sa4=75.0n sb1=75.0n sb2=75.0n sb3=75.0n spa=100n spa1=100n spa2=100n spa3=100n sap=91.9776n sapb=114.444n spba=115.715n spba1=117.043n dfm_flag=0 _ccoflag=1 _rcoflag=1 _rgflag=1 spmt=1.11111e+15 spomt=0 spomt1=1.11111e+60 spmb=1.11111e+15 spomb=0 spomb1=1.11111e+60
B1_Tm (B1_em nbias 0 0) nmos_lvt l=60n w=2u multi=1 nf=1 sd=100n ad=1.5e-13 as=1.5e-13 pd=4.15u ps=4.15u nrd=0.144730 nrs=0.144730 sa=75.0n sb=75.0n sa1=75.0n sa2=75.0n sa3=75.0n sa4=75.0n sb1=75.0n sb2=75.0n sb3=75.0n spa=100n spa1=100n spa2=100n spa3=100n sap=91.9776n sapb=120.93n spba=121.82n spba1=124.403n dfm_flag=0 _ccoflag=1 _rcoflag=1 _rgflag=1 spmt=1.11111e+15 spomt=0 spomt1=1.11111e+60 spmb=1.11111e+15 spomb=0 spomb1=1.11111e+60
B1_SN0m (B1_h0m B1_ck0 B1_fm 0) nmos_lvt l=30n w=2u multi=1 nf=1 sd=100n ad=1.5e-13 as=1.5e-13 pd=4.15u ps=4.15u nrd=0.144730 nrs=0.144730 sa=75.0n sb=75.0n sa1=75.0n sa2=75.0n sa3=75.0n sa4=75.0n sb1=75.0n sb2=75.0n sb3=75.0n spa=100n spa1=100n spa2=100n spa3=100n sap=91.9776n sapb=114.444n spba=115.715n spba1=117.043n dfm_flag=0 _ccoflag=1 _rcoflag=1 _rgflag=1 spmt=1.11111e+15 spomt=0 spomt1=1.11111e+60 spmb=1.11111e+15 spomb=0 spomb1=1.11111e+60
B1_SP0m (B1_h0m B1_kb0 B1_fm bankvdd) pmos_lvt l=30n w=2u multi=1 nf=1 sd=100n ad=1.5e-13 as=1.5e-13 pd=4.15u ps=4.15u nrd=0.082877 nrs=0.082877 sa=75.0n sb=75.0n sa1=75.0n sa2=75.0n sa3=75.0n sa4=75.0n sb1=75.0n sb2=75.0n sb3=75.0n spa=100n spa1=100n spa2=100n spa3=100n sap=91.9776n sapb=114.444n spba=115.715n spba1=117.043n dfm_flag=0 _ccoflag=1 _rcoflag=1 _rgflag=1 spmt=1.11111e+15 spomt=0 spomt1=1.11111e+60 spmb=1.11111e+15 spomb=0 spomb1=1.11111e+60
B1_CH0m (B1_h0m 0) capacitor c=2.5e-14
B1_RH0m (B1_h0m B1_fm) resistor r=1T
B1_SN1m (B1_h1m B1_ck1 B1_fm 0) nmos_lvt l=30n w=2u multi=1 nf=1 sd=100n ad=1.5e-13 as=1.5e-13 pd=4.15u ps=4.15u nrd=0.144730 nrs=0.144730 sa=75.0n sb=75.0n sa1=75.0n sa2=75.0n sa3=75.0n sa4=75.0n sb1=75.0n sb2=75.0n sb3=75.0n spa=100n spa1=100n spa2=100n spa3=100n sap=91.9776n sapb=114.444n spba=115.715n spba1=117.043n dfm_flag=0 _ccoflag=1 _rcoflag=1 _rgflag=1 spmt=1.11111e+15 spomt=0 spomt1=1.11111e+60 spmb=1.11111e+15 spomb=0 spomb1=1.11111e+60
B1_SP1m (B1_h1m B1_kb1 B1_fm bankvdd) pmos_lvt l=30n w=2u multi=1 nf=1 sd=100n ad=1.5e-13 as=1.5e-13 pd=4.15u ps=4.15u nrd=0.082877 nrs=0.082877 sa=75.0n sb=75.0n sa1=75.0n sa2=75.0n sa3=75.0n sa4=75.0n sb1=75.0n sb2=75.0n sb3=75.0n spa=100n spa1=100n spa2=100n spa3=100n sap=91.9776n sapb=114.444n spba=115.715n spba1=117.043n dfm_flag=0 _ccoflag=1 _rcoflag=1 _rgflag=1 spmt=1.11111e+15 spomt=0 spomt1=1.11111e+60 spmb=1.11111e+15 spomb=0 spomb1=1.11111e+60
B1_CH1m (B1_h1m 0) capacitor c=2.5e-14
B1_RH1m (B1_h1m B1_fm) resistor r=1T
B1_SN2m (B1_h2m B1_ck2 B1_fm 0) nmos_lvt l=30n w=2u multi=1 nf=1 sd=100n ad=1.5e-13 as=1.5e-13 pd=4.15u ps=4.15u nrd=0.144730 nrs=0.144730 sa=75.0n sb=75.0n sa1=75.0n sa2=75.0n sa3=75.0n sa4=75.0n sb1=75.0n sb2=75.0n sb3=75.0n spa=100n spa1=100n spa2=100n spa3=100n sap=91.9776n sapb=114.444n spba=115.715n spba1=117.043n dfm_flag=0 _ccoflag=1 _rcoflag=1 _rgflag=1 spmt=1.11111e+15 spomt=0 spomt1=1.11111e+60 spmb=1.11111e+15 spomb=0 spomb1=1.11111e+60
B1_SP2m (B1_h2m B1_kb2 B1_fm bankvdd) pmos_lvt l=30n w=2u multi=1 nf=1 sd=100n ad=1.5e-13 as=1.5e-13 pd=4.15u ps=4.15u nrd=0.082877 nrs=0.082877 sa=75.0n sb=75.0n sa1=75.0n sa2=75.0n sa3=75.0n sa4=75.0n sb1=75.0n sb2=75.0n sb3=75.0n spa=100n spa1=100n spa2=100n spa3=100n sap=91.9776n sapb=114.444n spba=115.715n spba1=117.043n dfm_flag=0 _ccoflag=1 _rcoflag=1 _rgflag=1 spmt=1.11111e+15 spomt=0 spomt1=1.11111e+60 spmb=1.11111e+15 spomb=0 spomb1=1.11111e+60
B1_CH2m (B1_h2m 0) capacitor c=2.5e-14
B1_RH2m (B1_h2m B1_fm) resistor r=1T
B1_SN3m (B1_h3m B1_ck3 B1_fm 0) nmos_lvt l=30n w=2u multi=1 nf=1 sd=100n ad=1.5e-13 as=1.5e-13 pd=4.15u ps=4.15u nrd=0.144730 nrs=0.144730 sa=75.0n sb=75.0n sa1=75.0n sa2=75.0n sa3=75.0n sa4=75.0n sb1=75.0n sb2=75.0n sb3=75.0n spa=100n spa1=100n spa2=100n spa3=100n sap=91.9776n sapb=114.444n spba=115.715n spba1=117.043n dfm_flag=0 _ccoflag=1 _rcoflag=1 _rgflag=1 spmt=1.11111e+15 spomt=0 spomt1=1.11111e+60 spmb=1.11111e+15 spomb=0 spomb1=1.11111e+60
B1_SP3m (B1_h3m B1_kb3 B1_fm bankvdd) pmos_lvt l=30n w=2u multi=1 nf=1 sd=100n ad=1.5e-13 as=1.5e-13 pd=4.15u ps=4.15u nrd=0.082877 nrs=0.082877 sa=75.0n sb=75.0n sa1=75.0n sa2=75.0n sa3=75.0n sa4=75.0n sb1=75.0n sb2=75.0n sb3=75.0n spa=100n spa1=100n spa2=100n spa3=100n sap=91.9776n sapb=114.444n spba=115.715n spba1=117.043n dfm_flag=0 _ccoflag=1 _rcoflag=1 _rgflag=1 spmt=1.11111e+15 spomt=0 spomt1=1.11111e+60 spmb=1.11111e+15 spomb=0 spomb1=1.11111e+60
B1_CH3m (B1_h3m 0) capacitor c=2.5e-14
B1_RH3m (B1_h3m B1_fm) resistor r=1T
B1_SN4m (B1_h4m B1_ck4 B1_fm 0) nmos_lvt l=30n w=2u multi=1 nf=1 sd=100n ad=1.5e-13 as=1.5e-13 pd=4.15u ps=4.15u nrd=0.144730 nrs=0.144730 sa=75.0n sb=75.0n sa1=75.0n sa2=75.0n sa3=75.0n sa4=75.0n sb1=75.0n sb2=75.0n sb3=75.0n spa=100n spa1=100n spa2=100n spa3=100n sap=91.9776n sapb=114.444n spba=115.715n spba1=117.043n dfm_flag=0 _ccoflag=1 _rcoflag=1 _rgflag=1 spmt=1.11111e+15 spomt=0 spomt1=1.11111e+60 spmb=1.11111e+15 spomb=0 spomb1=1.11111e+60
B1_SP4m (B1_h4m B1_kb4 B1_fm bankvdd) pmos_lvt l=30n w=2u multi=1 nf=1 sd=100n ad=1.5e-13 as=1.5e-13 pd=4.15u ps=4.15u nrd=0.082877 nrs=0.082877 sa=75.0n sb=75.0n sa1=75.0n sa2=75.0n sa3=75.0n sa4=75.0n sb1=75.0n sb2=75.0n sb3=75.0n spa=100n spa1=100n spa2=100n spa3=100n sap=91.9776n sapb=114.444n spba=115.715n spba1=117.043n dfm_flag=0 _ccoflag=1 _rcoflag=1 _rgflag=1 spmt=1.11111e+15 spomt=0 spomt1=1.11111e+60 spmb=1.11111e+15 spomb=0 spomb1=1.11111e+60
B1_CH4m (B1_h4m 0) capacitor c=2.5e-14
B1_RH4m (B1_h4m B1_fm) resistor r=1T
B1_SN5m (B1_h5m B1_ck5 B1_fm 0) nmos_lvt l=30n w=2u multi=1 nf=1 sd=100n ad=1.5e-13 as=1.5e-13 pd=4.15u ps=4.15u nrd=0.144730 nrs=0.144730 sa=75.0n sb=75.0n sa1=75.0n sa2=75.0n sa3=75.0n sa4=75.0n sb1=75.0n sb2=75.0n sb3=75.0n spa=100n spa1=100n spa2=100n spa3=100n sap=91.9776n sapb=114.444n spba=115.715n spba1=117.043n dfm_flag=0 _ccoflag=1 _rcoflag=1 _rgflag=1 spmt=1.11111e+15 spomt=0 spomt1=1.11111e+60 spmb=1.11111e+15 spomb=0 spomb1=1.11111e+60
B1_SP5m (B1_h5m B1_kb5 B1_fm bankvdd) pmos_lvt l=30n w=2u multi=1 nf=1 sd=100n ad=1.5e-13 as=1.5e-13 pd=4.15u ps=4.15u nrd=0.082877 nrs=0.082877 sa=75.0n sb=75.0n sa1=75.0n sa2=75.0n sa3=75.0n sa4=75.0n sb1=75.0n sb2=75.0n sb3=75.0n spa=100n spa1=100n spa2=100n spa3=100n sap=91.9776n sapb=114.444n spba=115.715n spba1=117.043n dfm_flag=0 _ccoflag=1 _rcoflag=1 _rgflag=1 spmt=1.11111e+15 spomt=0 spomt1=1.11111e+60 spmb=1.11111e+15 spomb=0 spomb1=1.11111e+60
B1_CH5m (B1_h5m 0) capacitor c=2.5e-14
B1_RH5m (B1_h5m B1_fm) resistor r=1T
B1_SN6m (B1_h6m B1_ck6 B1_fm 0) nmos_lvt l=30n w=2u multi=1 nf=1 sd=100n ad=1.5e-13 as=1.5e-13 pd=4.15u ps=4.15u nrd=0.144730 nrs=0.144730 sa=75.0n sb=75.0n sa1=75.0n sa2=75.0n sa3=75.0n sa4=75.0n sb1=75.0n sb2=75.0n sb3=75.0n spa=100n spa1=100n spa2=100n spa3=100n sap=91.9776n sapb=114.444n spba=115.715n spba1=117.043n dfm_flag=0 _ccoflag=1 _rcoflag=1 _rgflag=1 spmt=1.11111e+15 spomt=0 spomt1=1.11111e+60 spmb=1.11111e+15 spomb=0 spomb1=1.11111e+60
B1_SP6m (B1_h6m B1_kb6 B1_fm bankvdd) pmos_lvt l=30n w=2u multi=1 nf=1 sd=100n ad=1.5e-13 as=1.5e-13 pd=4.15u ps=4.15u nrd=0.082877 nrs=0.082877 sa=75.0n sb=75.0n sa1=75.0n sa2=75.0n sa3=75.0n sa4=75.0n sb1=75.0n sb2=75.0n sb3=75.0n spa=100n spa1=100n spa2=100n spa3=100n sap=91.9776n sapb=114.444n spba=115.715n spba1=117.043n dfm_flag=0 _ccoflag=1 _rcoflag=1 _rgflag=1 spmt=1.11111e+15 spomt=0 spomt1=1.11111e+60 spmb=1.11111e+15 spomb=0 spomb1=1.11111e+60
B1_CH6m (B1_h6m 0) capacitor c=2.5e-14
B1_RH6m (B1_h6m B1_fm) resistor r=1T
B1_SN7m (B1_h7m B1_ck7 B1_fm 0) nmos_lvt l=30n w=2u multi=1 nf=1 sd=100n ad=1.5e-13 as=1.5e-13 pd=4.15u ps=4.15u nrd=0.144730 nrs=0.144730 sa=75.0n sb=75.0n sa1=75.0n sa2=75.0n sa3=75.0n sa4=75.0n sb1=75.0n sb2=75.0n sb3=75.0n spa=100n spa1=100n spa2=100n spa3=100n sap=91.9776n sapb=114.444n spba=115.715n spba1=117.043n dfm_flag=0 _ccoflag=1 _rcoflag=1 _rgflag=1 spmt=1.11111e+15 spomt=0 spomt1=1.11111e+60 spmb=1.11111e+15 spomb=0 spomb1=1.11111e+60
B1_SP7m (B1_h7m B1_kb7 B1_fm bankvdd) pmos_lvt l=30n w=2u multi=1 nf=1 sd=100n ad=1.5e-13 as=1.5e-13 pd=4.15u ps=4.15u nrd=0.082877 nrs=0.082877 sa=75.0n sb=75.0n sa1=75.0n sa2=75.0n sa3=75.0n sa4=75.0n sb1=75.0n sb2=75.0n sb3=75.0n spa=100n spa1=100n spa2=100n spa3=100n sap=91.9776n sapb=114.444n spba=115.715n spba1=117.043n dfm_flag=0 _ccoflag=1 _rcoflag=1 _rgflag=1 spmt=1.11111e+15 spomt=0 spomt1=1.11111e+60 spmb=1.11111e+15 spomb=0 spomb1=1.11111e+60
B1_CH7m (B1_h7m 0) capacitor c=2.5e-14
B1_RH7m (B1_h7m B1_fm) resistor r=1T
B1_RDEG (B1_ep B1_em) resistor r=250
B1_COMP0 (B1_h0p B1_h0m compvdd logicvdd) COMPLOAD
B1_COMP1 (B1_h1p B1_h1m compvdd logicvdd) COMPLOAD
B1_COMP2 (B1_h2p B1_h2m compvdd logicvdd) COMPLOAD
B1_COMP3 (B1_h3p B1_h3m compvdd logicvdd) COMPLOAD
B1_COMP4 (B1_h4p B1_h4m compvdd logicvdd) COMPLOAD
B1_COMP5 (B1_h5p B1_h5m compvdd logicvdd) COMPLOAD
B1_COMP6 (B1_h6p B1_h6m compvdd logicvdd) COMPLOAD
B1_COMP7 (B1_h7p B1_h7m compvdd logicvdd) COMPLOAD
B2_ck0V (B2_ck0 0) vsource type=pulse val0=0 val1=0.9 delay=1.220891428571429e-10 rise=1e-12 fall=1e-12 width=6.471429999999999e-11 period=5.714288e-10
B2_kb0V (B2_kb0 0) vsource type=pulse val0=0.9 val1=0 delay=1.220891428571429e-10 rise=1e-12 fall=1e-12 width=6.471429999999999e-11 period=5.714288e-10
B2_ck1V (B2_ck1 0) vsource type=pulse val0=0 val1=0.9 delay=1.935177428571429e-10 rise=1e-12 fall=1e-12 width=6.471429999999999e-11 period=5.714288e-10
B2_kb1V (B2_kb1 0) vsource type=pulse val0=0.9 val1=0 delay=1.935177428571429e-10 rise=1e-12 fall=1e-12 width=6.471429999999999e-11 period=5.714288e-10
B2_ck2V (B2_ck2 0) vsource type=pulse val0=0 val1=0.9 delay=2.649463428571429e-10 rise=1e-12 fall=1e-12 width=6.471429999999999e-11 period=5.714288e-10
B2_kb2V (B2_kb2 0) vsource type=pulse val0=0.9 val1=0 delay=2.649463428571429e-10 rise=1e-12 fall=1e-12 width=6.471429999999999e-11 period=5.714288e-10
B2_ck3V (B2_ck3 0) vsource type=pulse val0=0 val1=0.9 delay=3.363749428571429e-10 rise=1e-12 fall=1e-12 width=6.471429999999999e-11 period=5.714288e-10
B2_kb3V (B2_kb3 0) vsource type=pulse val0=0.9 val1=0 delay=3.363749428571429e-10 rise=1e-12 fall=1e-12 width=6.471429999999999e-11 period=5.714288e-10
B2_ck4V (B2_ck4 0) vsource type=pulse val0=0 val1=0.9 delay=4.078035428571429e-10 rise=1e-12 fall=1e-12 width=6.471429999999999e-11 period=5.714288e-10
B2_kb4V (B2_kb4 0) vsource type=pulse val0=0.9 val1=0 delay=4.078035428571429e-10 rise=1e-12 fall=1e-12 width=6.471429999999999e-11 period=5.714288e-10
B2_ck5V (B2_ck5 0) vsource type=pulse val0=0 val1=0.9 delay=4.792321428571429e-10 rise=1e-12 fall=1e-12 width=6.471429999999999e-11 period=5.714288e-10
B2_kb5V (B2_kb5 0) vsource type=pulse val0=0.9 val1=0 delay=4.792321428571429e-10 rise=1e-12 fall=1e-12 width=6.471429999999999e-11 period=5.714288e-10
B2_ck6V (B2_ck6 0) vsource type=pulse val0=0 val1=0.9 delay=5.506607428571429e-10 rise=1e-12 fall=1e-12 width=6.471429999999999e-11 period=5.714288e-10
B2_kb6V (B2_kb6 0) vsource type=pulse val0=0.9 val1=0 delay=5.506607428571429e-10 rise=1e-12 fall=1e-12 width=6.471429999999999e-11 period=5.714288e-10
B2_ck7V (B2_ck7 0) vsource type=pulse val0=0 val1=0.9 delay=6.220893428571429e-10 rise=1e-12 fall=1e-12 width=6.471429999999999e-11 period=5.714288e-10
B2_kb7V (B2_kb7 0) vsource type=pulse val0=0.9 val1=0 delay=6.220893428571429e-10 rise=1e-12 fall=1e-12 width=6.471429999999999e-11 period=5.714288e-10
RB2_Lp (bankvdd B2_fp) resistor r=500
B2_Fp (B2_fp X_h2p B2_ep 0) nmos_lvt l=30n w=2u multi=1 nf=1 sd=100n ad=1.5e-13 as=1.5e-13 pd=4.15u ps=4.15u nrd=0.144730 nrs=0.144730 sa=75.0n sb=75.0n sa1=75.0n sa2=75.0n sa3=75.0n sa4=75.0n sb1=75.0n sb2=75.0n sb3=75.0n spa=100n spa1=100n spa2=100n spa3=100n sap=91.9776n sapb=114.444n spba=115.715n spba1=117.043n dfm_flag=0 _ccoflag=1 _rcoflag=1 _rgflag=1 spmt=1.11111e+15 spomt=0 spomt1=1.11111e+60 spmb=1.11111e+15 spomb=0 spomb1=1.11111e+60
B2_Tp (B2_ep nbias 0 0) nmos_lvt l=60n w=2u multi=1 nf=1 sd=100n ad=1.5e-13 as=1.5e-13 pd=4.15u ps=4.15u nrd=0.144730 nrs=0.144730 sa=75.0n sb=75.0n sa1=75.0n sa2=75.0n sa3=75.0n sa4=75.0n sb1=75.0n sb2=75.0n sb3=75.0n spa=100n spa1=100n spa2=100n spa3=100n sap=91.9776n sapb=120.93n spba=121.82n spba1=124.403n dfm_flag=0 _ccoflag=1 _rcoflag=1 _rgflag=1 spmt=1.11111e+15 spomt=0 spomt1=1.11111e+60 spmb=1.11111e+15 spomb=0 spomb1=1.11111e+60
B2_SN0p (B2_h0p B2_ck0 B2_fp 0) nmos_lvt l=30n w=2u multi=1 nf=1 sd=100n ad=1.5e-13 as=1.5e-13 pd=4.15u ps=4.15u nrd=0.144730 nrs=0.144730 sa=75.0n sb=75.0n sa1=75.0n sa2=75.0n sa3=75.0n sa4=75.0n sb1=75.0n sb2=75.0n sb3=75.0n spa=100n spa1=100n spa2=100n spa3=100n sap=91.9776n sapb=114.444n spba=115.715n spba1=117.043n dfm_flag=0 _ccoflag=1 _rcoflag=1 _rgflag=1 spmt=1.11111e+15 spomt=0 spomt1=1.11111e+60 spmb=1.11111e+15 spomb=0 spomb1=1.11111e+60
B2_SP0p (B2_h0p B2_kb0 B2_fp bankvdd) pmos_lvt l=30n w=2u multi=1 nf=1 sd=100n ad=1.5e-13 as=1.5e-13 pd=4.15u ps=4.15u nrd=0.082877 nrs=0.082877 sa=75.0n sb=75.0n sa1=75.0n sa2=75.0n sa3=75.0n sa4=75.0n sb1=75.0n sb2=75.0n sb3=75.0n spa=100n spa1=100n spa2=100n spa3=100n sap=91.9776n sapb=114.444n spba=115.715n spba1=117.043n dfm_flag=0 _ccoflag=1 _rcoflag=1 _rgflag=1 spmt=1.11111e+15 spomt=0 spomt1=1.11111e+60 spmb=1.11111e+15 spomb=0 spomb1=1.11111e+60
B2_CH0p (B2_h0p 0) capacitor c=2.5e-14
B2_RH0p (B2_h0p B2_fp) resistor r=1T
B2_SN1p (B2_h1p B2_ck1 B2_fp 0) nmos_lvt l=30n w=2u multi=1 nf=1 sd=100n ad=1.5e-13 as=1.5e-13 pd=4.15u ps=4.15u nrd=0.144730 nrs=0.144730 sa=75.0n sb=75.0n sa1=75.0n sa2=75.0n sa3=75.0n sa4=75.0n sb1=75.0n sb2=75.0n sb3=75.0n spa=100n spa1=100n spa2=100n spa3=100n sap=91.9776n sapb=114.444n spba=115.715n spba1=117.043n dfm_flag=0 _ccoflag=1 _rcoflag=1 _rgflag=1 spmt=1.11111e+15 spomt=0 spomt1=1.11111e+60 spmb=1.11111e+15 spomb=0 spomb1=1.11111e+60
B2_SP1p (B2_h1p B2_kb1 B2_fp bankvdd) pmos_lvt l=30n w=2u multi=1 nf=1 sd=100n ad=1.5e-13 as=1.5e-13 pd=4.15u ps=4.15u nrd=0.082877 nrs=0.082877 sa=75.0n sb=75.0n sa1=75.0n sa2=75.0n sa3=75.0n sa4=75.0n sb1=75.0n sb2=75.0n sb3=75.0n spa=100n spa1=100n spa2=100n spa3=100n sap=91.9776n sapb=114.444n spba=115.715n spba1=117.043n dfm_flag=0 _ccoflag=1 _rcoflag=1 _rgflag=1 spmt=1.11111e+15 spomt=0 spomt1=1.11111e+60 spmb=1.11111e+15 spomb=0 spomb1=1.11111e+60
B2_CH1p (B2_h1p 0) capacitor c=2.5e-14
B2_RH1p (B2_h1p B2_fp) resistor r=1T
B2_SN2p (B2_h2p B2_ck2 B2_fp 0) nmos_lvt l=30n w=2u multi=1 nf=1 sd=100n ad=1.5e-13 as=1.5e-13 pd=4.15u ps=4.15u nrd=0.144730 nrs=0.144730 sa=75.0n sb=75.0n sa1=75.0n sa2=75.0n sa3=75.0n sa4=75.0n sb1=75.0n sb2=75.0n sb3=75.0n spa=100n spa1=100n spa2=100n spa3=100n sap=91.9776n sapb=114.444n spba=115.715n spba1=117.043n dfm_flag=0 _ccoflag=1 _rcoflag=1 _rgflag=1 spmt=1.11111e+15 spomt=0 spomt1=1.11111e+60 spmb=1.11111e+15 spomb=0 spomb1=1.11111e+60
B2_SP2p (B2_h2p B2_kb2 B2_fp bankvdd) pmos_lvt l=30n w=2u multi=1 nf=1 sd=100n ad=1.5e-13 as=1.5e-13 pd=4.15u ps=4.15u nrd=0.082877 nrs=0.082877 sa=75.0n sb=75.0n sa1=75.0n sa2=75.0n sa3=75.0n sa4=75.0n sb1=75.0n sb2=75.0n sb3=75.0n spa=100n spa1=100n spa2=100n spa3=100n sap=91.9776n sapb=114.444n spba=115.715n spba1=117.043n dfm_flag=0 _ccoflag=1 _rcoflag=1 _rgflag=1 spmt=1.11111e+15 spomt=0 spomt1=1.11111e+60 spmb=1.11111e+15 spomb=0 spomb1=1.11111e+60
B2_CH2p (B2_h2p 0) capacitor c=2.5e-14
B2_RH2p (B2_h2p B2_fp) resistor r=1T
B2_SN3p (B2_h3p B2_ck3 B2_fp 0) nmos_lvt l=30n w=2u multi=1 nf=1 sd=100n ad=1.5e-13 as=1.5e-13 pd=4.15u ps=4.15u nrd=0.144730 nrs=0.144730 sa=75.0n sb=75.0n sa1=75.0n sa2=75.0n sa3=75.0n sa4=75.0n sb1=75.0n sb2=75.0n sb3=75.0n spa=100n spa1=100n spa2=100n spa3=100n sap=91.9776n sapb=114.444n spba=115.715n spba1=117.043n dfm_flag=0 _ccoflag=1 _rcoflag=1 _rgflag=1 spmt=1.11111e+15 spomt=0 spomt1=1.11111e+60 spmb=1.11111e+15 spomb=0 spomb1=1.11111e+60
B2_SP3p (B2_h3p B2_kb3 B2_fp bankvdd) pmos_lvt l=30n w=2u multi=1 nf=1 sd=100n ad=1.5e-13 as=1.5e-13 pd=4.15u ps=4.15u nrd=0.082877 nrs=0.082877 sa=75.0n sb=75.0n sa1=75.0n sa2=75.0n sa3=75.0n sa4=75.0n sb1=75.0n sb2=75.0n sb3=75.0n spa=100n spa1=100n spa2=100n spa3=100n sap=91.9776n sapb=114.444n spba=115.715n spba1=117.043n dfm_flag=0 _ccoflag=1 _rcoflag=1 _rgflag=1 spmt=1.11111e+15 spomt=0 spomt1=1.11111e+60 spmb=1.11111e+15 spomb=0 spomb1=1.11111e+60
B2_CH3p (B2_h3p 0) capacitor c=2.5e-14
B2_RH3p (B2_h3p B2_fp) resistor r=1T
B2_SN4p (B2_h4p B2_ck4 B2_fp 0) nmos_lvt l=30n w=2u multi=1 nf=1 sd=100n ad=1.5e-13 as=1.5e-13 pd=4.15u ps=4.15u nrd=0.144730 nrs=0.144730 sa=75.0n sb=75.0n sa1=75.0n sa2=75.0n sa3=75.0n sa4=75.0n sb1=75.0n sb2=75.0n sb3=75.0n spa=100n spa1=100n spa2=100n spa3=100n sap=91.9776n sapb=114.444n spba=115.715n spba1=117.043n dfm_flag=0 _ccoflag=1 _rcoflag=1 _rgflag=1 spmt=1.11111e+15 spomt=0 spomt1=1.11111e+60 spmb=1.11111e+15 spomb=0 spomb1=1.11111e+60
B2_SP4p (B2_h4p B2_kb4 B2_fp bankvdd) pmos_lvt l=30n w=2u multi=1 nf=1 sd=100n ad=1.5e-13 as=1.5e-13 pd=4.15u ps=4.15u nrd=0.082877 nrs=0.082877 sa=75.0n sb=75.0n sa1=75.0n sa2=75.0n sa3=75.0n sa4=75.0n sb1=75.0n sb2=75.0n sb3=75.0n spa=100n spa1=100n spa2=100n spa3=100n sap=91.9776n sapb=114.444n spba=115.715n spba1=117.043n dfm_flag=0 _ccoflag=1 _rcoflag=1 _rgflag=1 spmt=1.11111e+15 spomt=0 spomt1=1.11111e+60 spmb=1.11111e+15 spomb=0 spomb1=1.11111e+60
B2_CH4p (B2_h4p 0) capacitor c=2.5e-14
B2_RH4p (B2_h4p B2_fp) resistor r=1T
B2_SN5p (B2_h5p B2_ck5 B2_fp 0) nmos_lvt l=30n w=2u multi=1 nf=1 sd=100n ad=1.5e-13 as=1.5e-13 pd=4.15u ps=4.15u nrd=0.144730 nrs=0.144730 sa=75.0n sb=75.0n sa1=75.0n sa2=75.0n sa3=75.0n sa4=75.0n sb1=75.0n sb2=75.0n sb3=75.0n spa=100n spa1=100n spa2=100n spa3=100n sap=91.9776n sapb=114.444n spba=115.715n spba1=117.043n dfm_flag=0 _ccoflag=1 _rcoflag=1 _rgflag=1 spmt=1.11111e+15 spomt=0 spomt1=1.11111e+60 spmb=1.11111e+15 spomb=0 spomb1=1.11111e+60
B2_SP5p (B2_h5p B2_kb5 B2_fp bankvdd) pmos_lvt l=30n w=2u multi=1 nf=1 sd=100n ad=1.5e-13 as=1.5e-13 pd=4.15u ps=4.15u nrd=0.082877 nrs=0.082877 sa=75.0n sb=75.0n sa1=75.0n sa2=75.0n sa3=75.0n sa4=75.0n sb1=75.0n sb2=75.0n sb3=75.0n spa=100n spa1=100n spa2=100n spa3=100n sap=91.9776n sapb=114.444n spba=115.715n spba1=117.043n dfm_flag=0 _ccoflag=1 _rcoflag=1 _rgflag=1 spmt=1.11111e+15 spomt=0 spomt1=1.11111e+60 spmb=1.11111e+15 spomb=0 spomb1=1.11111e+60
B2_CH5p (B2_h5p 0) capacitor c=2.5e-14
B2_RH5p (B2_h5p B2_fp) resistor r=1T
B2_SN6p (B2_h6p B2_ck6 B2_fp 0) nmos_lvt l=30n w=2u multi=1 nf=1 sd=100n ad=1.5e-13 as=1.5e-13 pd=4.15u ps=4.15u nrd=0.144730 nrs=0.144730 sa=75.0n sb=75.0n sa1=75.0n sa2=75.0n sa3=75.0n sa4=75.0n sb1=75.0n sb2=75.0n sb3=75.0n spa=100n spa1=100n spa2=100n spa3=100n sap=91.9776n sapb=114.444n spba=115.715n spba1=117.043n dfm_flag=0 _ccoflag=1 _rcoflag=1 _rgflag=1 spmt=1.11111e+15 spomt=0 spomt1=1.11111e+60 spmb=1.11111e+15 spomb=0 spomb1=1.11111e+60
B2_SP6p (B2_h6p B2_kb6 B2_fp bankvdd) pmos_lvt l=30n w=2u multi=1 nf=1 sd=100n ad=1.5e-13 as=1.5e-13 pd=4.15u ps=4.15u nrd=0.082877 nrs=0.082877 sa=75.0n sb=75.0n sa1=75.0n sa2=75.0n sa3=75.0n sa4=75.0n sb1=75.0n sb2=75.0n sb3=75.0n spa=100n spa1=100n spa2=100n spa3=100n sap=91.9776n sapb=114.444n spba=115.715n spba1=117.043n dfm_flag=0 _ccoflag=1 _rcoflag=1 _rgflag=1 spmt=1.11111e+15 spomt=0 spomt1=1.11111e+60 spmb=1.11111e+15 spomb=0 spomb1=1.11111e+60
B2_CH6p (B2_h6p 0) capacitor c=2.5e-14
B2_RH6p (B2_h6p B2_fp) resistor r=1T
B2_SN7p (B2_h7p B2_ck7 B2_fp 0) nmos_lvt l=30n w=2u multi=1 nf=1 sd=100n ad=1.5e-13 as=1.5e-13 pd=4.15u ps=4.15u nrd=0.144730 nrs=0.144730 sa=75.0n sb=75.0n sa1=75.0n sa2=75.0n sa3=75.0n sa4=75.0n sb1=75.0n sb2=75.0n sb3=75.0n spa=100n spa1=100n spa2=100n spa3=100n sap=91.9776n sapb=114.444n spba=115.715n spba1=117.043n dfm_flag=0 _ccoflag=1 _rcoflag=1 _rgflag=1 spmt=1.11111e+15 spomt=0 spomt1=1.11111e+60 spmb=1.11111e+15 spomb=0 spomb1=1.11111e+60
B2_SP7p (B2_h7p B2_kb7 B2_fp bankvdd) pmos_lvt l=30n w=2u multi=1 nf=1 sd=100n ad=1.5e-13 as=1.5e-13 pd=4.15u ps=4.15u nrd=0.082877 nrs=0.082877 sa=75.0n sb=75.0n sa1=75.0n sa2=75.0n sa3=75.0n sa4=75.0n sb1=75.0n sb2=75.0n sb3=75.0n spa=100n spa1=100n spa2=100n spa3=100n sap=91.9776n sapb=114.444n spba=115.715n spba1=117.043n dfm_flag=0 _ccoflag=1 _rcoflag=1 _rgflag=1 spmt=1.11111e+15 spomt=0 spomt1=1.11111e+60 spmb=1.11111e+15 spomb=0 spomb1=1.11111e+60
B2_CH7p (B2_h7p 0) capacitor c=2.5e-14
B2_RH7p (B2_h7p B2_fp) resistor r=1T
RB2_Lm (bankvdd B2_fm) resistor r=500
B2_Fm (B2_fm X_h2m B2_em 0) nmos_lvt l=30n w=2u multi=1 nf=1 sd=100n ad=1.5e-13 as=1.5e-13 pd=4.15u ps=4.15u nrd=0.144730 nrs=0.144730 sa=75.0n sb=75.0n sa1=75.0n sa2=75.0n sa3=75.0n sa4=75.0n sb1=75.0n sb2=75.0n sb3=75.0n spa=100n spa1=100n spa2=100n spa3=100n sap=91.9776n sapb=114.444n spba=115.715n spba1=117.043n dfm_flag=0 _ccoflag=1 _rcoflag=1 _rgflag=1 spmt=1.11111e+15 spomt=0 spomt1=1.11111e+60 spmb=1.11111e+15 spomb=0 spomb1=1.11111e+60
B2_Tm (B2_em nbias 0 0) nmos_lvt l=60n w=2u multi=1 nf=1 sd=100n ad=1.5e-13 as=1.5e-13 pd=4.15u ps=4.15u nrd=0.144730 nrs=0.144730 sa=75.0n sb=75.0n sa1=75.0n sa2=75.0n sa3=75.0n sa4=75.0n sb1=75.0n sb2=75.0n sb3=75.0n spa=100n spa1=100n spa2=100n spa3=100n sap=91.9776n sapb=120.93n spba=121.82n spba1=124.403n dfm_flag=0 _ccoflag=1 _rcoflag=1 _rgflag=1 spmt=1.11111e+15 spomt=0 spomt1=1.11111e+60 spmb=1.11111e+15 spomb=0 spomb1=1.11111e+60
B2_SN0m (B2_h0m B2_ck0 B2_fm 0) nmos_lvt l=30n w=2u multi=1 nf=1 sd=100n ad=1.5e-13 as=1.5e-13 pd=4.15u ps=4.15u nrd=0.144730 nrs=0.144730 sa=75.0n sb=75.0n sa1=75.0n sa2=75.0n sa3=75.0n sa4=75.0n sb1=75.0n sb2=75.0n sb3=75.0n spa=100n spa1=100n spa2=100n spa3=100n sap=91.9776n sapb=114.444n spba=115.715n spba1=117.043n dfm_flag=0 _ccoflag=1 _rcoflag=1 _rgflag=1 spmt=1.11111e+15 spomt=0 spomt1=1.11111e+60 spmb=1.11111e+15 spomb=0 spomb1=1.11111e+60
B2_SP0m (B2_h0m B2_kb0 B2_fm bankvdd) pmos_lvt l=30n w=2u multi=1 nf=1 sd=100n ad=1.5e-13 as=1.5e-13 pd=4.15u ps=4.15u nrd=0.082877 nrs=0.082877 sa=75.0n sb=75.0n sa1=75.0n sa2=75.0n sa3=75.0n sa4=75.0n sb1=75.0n sb2=75.0n sb3=75.0n spa=100n spa1=100n spa2=100n spa3=100n sap=91.9776n sapb=114.444n spba=115.715n spba1=117.043n dfm_flag=0 _ccoflag=1 _rcoflag=1 _rgflag=1 spmt=1.11111e+15 spomt=0 spomt1=1.11111e+60 spmb=1.11111e+15 spomb=0 spomb1=1.11111e+60
B2_CH0m (B2_h0m 0) capacitor c=2.5e-14
B2_RH0m (B2_h0m B2_fm) resistor r=1T
B2_SN1m (B2_h1m B2_ck1 B2_fm 0) nmos_lvt l=30n w=2u multi=1 nf=1 sd=100n ad=1.5e-13 as=1.5e-13 pd=4.15u ps=4.15u nrd=0.144730 nrs=0.144730 sa=75.0n sb=75.0n sa1=75.0n sa2=75.0n sa3=75.0n sa4=75.0n sb1=75.0n sb2=75.0n sb3=75.0n spa=100n spa1=100n spa2=100n spa3=100n sap=91.9776n sapb=114.444n spba=115.715n spba1=117.043n dfm_flag=0 _ccoflag=1 _rcoflag=1 _rgflag=1 spmt=1.11111e+15 spomt=0 spomt1=1.11111e+60 spmb=1.11111e+15 spomb=0 spomb1=1.11111e+60
B2_SP1m (B2_h1m B2_kb1 B2_fm bankvdd) pmos_lvt l=30n w=2u multi=1 nf=1 sd=100n ad=1.5e-13 as=1.5e-13 pd=4.15u ps=4.15u nrd=0.082877 nrs=0.082877 sa=75.0n sb=75.0n sa1=75.0n sa2=75.0n sa3=75.0n sa4=75.0n sb1=75.0n sb2=75.0n sb3=75.0n spa=100n spa1=100n spa2=100n spa3=100n sap=91.9776n sapb=114.444n spba=115.715n spba1=117.043n dfm_flag=0 _ccoflag=1 _rcoflag=1 _rgflag=1 spmt=1.11111e+15 spomt=0 spomt1=1.11111e+60 spmb=1.11111e+15 spomb=0 spomb1=1.11111e+60
B2_CH1m (B2_h1m 0) capacitor c=2.5e-14
B2_RH1m (B2_h1m B2_fm) resistor r=1T
B2_SN2m (B2_h2m B2_ck2 B2_fm 0) nmos_lvt l=30n w=2u multi=1 nf=1 sd=100n ad=1.5e-13 as=1.5e-13 pd=4.15u ps=4.15u nrd=0.144730 nrs=0.144730 sa=75.0n sb=75.0n sa1=75.0n sa2=75.0n sa3=75.0n sa4=75.0n sb1=75.0n sb2=75.0n sb3=75.0n spa=100n spa1=100n spa2=100n spa3=100n sap=91.9776n sapb=114.444n spba=115.715n spba1=117.043n dfm_flag=0 _ccoflag=1 _rcoflag=1 _rgflag=1 spmt=1.11111e+15 spomt=0 spomt1=1.11111e+60 spmb=1.11111e+15 spomb=0 spomb1=1.11111e+60
B2_SP2m (B2_h2m B2_kb2 B2_fm bankvdd) pmos_lvt l=30n w=2u multi=1 nf=1 sd=100n ad=1.5e-13 as=1.5e-13 pd=4.15u ps=4.15u nrd=0.082877 nrs=0.082877 sa=75.0n sb=75.0n sa1=75.0n sa2=75.0n sa3=75.0n sa4=75.0n sb1=75.0n sb2=75.0n sb3=75.0n spa=100n spa1=100n spa2=100n spa3=100n sap=91.9776n sapb=114.444n spba=115.715n spba1=117.043n dfm_flag=0 _ccoflag=1 _rcoflag=1 _rgflag=1 spmt=1.11111e+15 spomt=0 spomt1=1.11111e+60 spmb=1.11111e+15 spomb=0 spomb1=1.11111e+60
B2_CH2m (B2_h2m 0) capacitor c=2.5e-14
B2_RH2m (B2_h2m B2_fm) resistor r=1T
B2_SN3m (B2_h3m B2_ck3 B2_fm 0) nmos_lvt l=30n w=2u multi=1 nf=1 sd=100n ad=1.5e-13 as=1.5e-13 pd=4.15u ps=4.15u nrd=0.144730 nrs=0.144730 sa=75.0n sb=75.0n sa1=75.0n sa2=75.0n sa3=75.0n sa4=75.0n sb1=75.0n sb2=75.0n sb3=75.0n spa=100n spa1=100n spa2=100n spa3=100n sap=91.9776n sapb=114.444n spba=115.715n spba1=117.043n dfm_flag=0 _ccoflag=1 _rcoflag=1 _rgflag=1 spmt=1.11111e+15 spomt=0 spomt1=1.11111e+60 spmb=1.11111e+15 spomb=0 spomb1=1.11111e+60
B2_SP3m (B2_h3m B2_kb3 B2_fm bankvdd) pmos_lvt l=30n w=2u multi=1 nf=1 sd=100n ad=1.5e-13 as=1.5e-13 pd=4.15u ps=4.15u nrd=0.082877 nrs=0.082877 sa=75.0n sb=75.0n sa1=75.0n sa2=75.0n sa3=75.0n sa4=75.0n sb1=75.0n sb2=75.0n sb3=75.0n spa=100n spa1=100n spa2=100n spa3=100n sap=91.9776n sapb=114.444n spba=115.715n spba1=117.043n dfm_flag=0 _ccoflag=1 _rcoflag=1 _rgflag=1 spmt=1.11111e+15 spomt=0 spomt1=1.11111e+60 spmb=1.11111e+15 spomb=0 spomb1=1.11111e+60
B2_CH3m (B2_h3m 0) capacitor c=2.5e-14
B2_RH3m (B2_h3m B2_fm) resistor r=1T
B2_SN4m (B2_h4m B2_ck4 B2_fm 0) nmos_lvt l=30n w=2u multi=1 nf=1 sd=100n ad=1.5e-13 as=1.5e-13 pd=4.15u ps=4.15u nrd=0.144730 nrs=0.144730 sa=75.0n sb=75.0n sa1=75.0n sa2=75.0n sa3=75.0n sa4=75.0n sb1=75.0n sb2=75.0n sb3=75.0n spa=100n spa1=100n spa2=100n spa3=100n sap=91.9776n sapb=114.444n spba=115.715n spba1=117.043n dfm_flag=0 _ccoflag=1 _rcoflag=1 _rgflag=1 spmt=1.11111e+15 spomt=0 spomt1=1.11111e+60 spmb=1.11111e+15 spomb=0 spomb1=1.11111e+60
B2_SP4m (B2_h4m B2_kb4 B2_fm bankvdd) pmos_lvt l=30n w=2u multi=1 nf=1 sd=100n ad=1.5e-13 as=1.5e-13 pd=4.15u ps=4.15u nrd=0.082877 nrs=0.082877 sa=75.0n sb=75.0n sa1=75.0n sa2=75.0n sa3=75.0n sa4=75.0n sb1=75.0n sb2=75.0n sb3=75.0n spa=100n spa1=100n spa2=100n spa3=100n sap=91.9776n sapb=114.444n spba=115.715n spba1=117.043n dfm_flag=0 _ccoflag=1 _rcoflag=1 _rgflag=1 spmt=1.11111e+15 spomt=0 spomt1=1.11111e+60 spmb=1.11111e+15 spomb=0 spomb1=1.11111e+60
B2_CH4m (B2_h4m 0) capacitor c=2.5e-14
B2_RH4m (B2_h4m B2_fm) resistor r=1T
B2_SN5m (B2_h5m B2_ck5 B2_fm 0) nmos_lvt l=30n w=2u multi=1 nf=1 sd=100n ad=1.5e-13 as=1.5e-13 pd=4.15u ps=4.15u nrd=0.144730 nrs=0.144730 sa=75.0n sb=75.0n sa1=75.0n sa2=75.0n sa3=75.0n sa4=75.0n sb1=75.0n sb2=75.0n sb3=75.0n spa=100n spa1=100n spa2=100n spa3=100n sap=91.9776n sapb=114.444n spba=115.715n spba1=117.043n dfm_flag=0 _ccoflag=1 _rcoflag=1 _rgflag=1 spmt=1.11111e+15 spomt=0 spomt1=1.11111e+60 spmb=1.11111e+15 spomb=0 spomb1=1.11111e+60
B2_SP5m (B2_h5m B2_kb5 B2_fm bankvdd) pmos_lvt l=30n w=2u multi=1 nf=1 sd=100n ad=1.5e-13 as=1.5e-13 pd=4.15u ps=4.15u nrd=0.082877 nrs=0.082877 sa=75.0n sb=75.0n sa1=75.0n sa2=75.0n sa3=75.0n sa4=75.0n sb1=75.0n sb2=75.0n sb3=75.0n spa=100n spa1=100n spa2=100n spa3=100n sap=91.9776n sapb=114.444n spba=115.715n spba1=117.043n dfm_flag=0 _ccoflag=1 _rcoflag=1 _rgflag=1 spmt=1.11111e+15 spomt=0 spomt1=1.11111e+60 spmb=1.11111e+15 spomb=0 spomb1=1.11111e+60
B2_CH5m (B2_h5m 0) capacitor c=2.5e-14
B2_RH5m (B2_h5m B2_fm) resistor r=1T
B2_SN6m (B2_h6m B2_ck6 B2_fm 0) nmos_lvt l=30n w=2u multi=1 nf=1 sd=100n ad=1.5e-13 as=1.5e-13 pd=4.15u ps=4.15u nrd=0.144730 nrs=0.144730 sa=75.0n sb=75.0n sa1=75.0n sa2=75.0n sa3=75.0n sa4=75.0n sb1=75.0n sb2=75.0n sb3=75.0n spa=100n spa1=100n spa2=100n spa3=100n sap=91.9776n sapb=114.444n spba=115.715n spba1=117.043n dfm_flag=0 _ccoflag=1 _rcoflag=1 _rgflag=1 spmt=1.11111e+15 spomt=0 spomt1=1.11111e+60 spmb=1.11111e+15 spomb=0 spomb1=1.11111e+60
B2_SP6m (B2_h6m B2_kb6 B2_fm bankvdd) pmos_lvt l=30n w=2u multi=1 nf=1 sd=100n ad=1.5e-13 as=1.5e-13 pd=4.15u ps=4.15u nrd=0.082877 nrs=0.082877 sa=75.0n sb=75.0n sa1=75.0n sa2=75.0n sa3=75.0n sa4=75.0n sb1=75.0n sb2=75.0n sb3=75.0n spa=100n spa1=100n spa2=100n spa3=100n sap=91.9776n sapb=114.444n spba=115.715n spba1=117.043n dfm_flag=0 _ccoflag=1 _rcoflag=1 _rgflag=1 spmt=1.11111e+15 spomt=0 spomt1=1.11111e+60 spmb=1.11111e+15 spomb=0 spomb1=1.11111e+60
B2_CH6m (B2_h6m 0) capacitor c=2.5e-14
B2_RH6m (B2_h6m B2_fm) resistor r=1T
B2_SN7m (B2_h7m B2_ck7 B2_fm 0) nmos_lvt l=30n w=2u multi=1 nf=1 sd=100n ad=1.5e-13 as=1.5e-13 pd=4.15u ps=4.15u nrd=0.144730 nrs=0.144730 sa=75.0n sb=75.0n sa1=75.0n sa2=75.0n sa3=75.0n sa4=75.0n sb1=75.0n sb2=75.0n sb3=75.0n spa=100n spa1=100n spa2=100n spa3=100n sap=91.9776n sapb=114.444n spba=115.715n spba1=117.043n dfm_flag=0 _ccoflag=1 _rcoflag=1 _rgflag=1 spmt=1.11111e+15 spomt=0 spomt1=1.11111e+60 spmb=1.11111e+15 spomb=0 spomb1=1.11111e+60
B2_SP7m (B2_h7m B2_kb7 B2_fm bankvdd) pmos_lvt l=30n w=2u multi=1 nf=1 sd=100n ad=1.5e-13 as=1.5e-13 pd=4.15u ps=4.15u nrd=0.082877 nrs=0.082877 sa=75.0n sb=75.0n sa1=75.0n sa2=75.0n sa3=75.0n sa4=75.0n sb1=75.0n sb2=75.0n sb3=75.0n spa=100n spa1=100n spa2=100n spa3=100n sap=91.9776n sapb=114.444n spba=115.715n spba1=117.043n dfm_flag=0 _ccoflag=1 _rcoflag=1 _rgflag=1 spmt=1.11111e+15 spomt=0 spomt1=1.11111e+60 spmb=1.11111e+15 spomb=0 spomb1=1.11111e+60
B2_CH7m (B2_h7m 0) capacitor c=2.5e-14
B2_RH7m (B2_h7m B2_fm) resistor r=1T
B2_RDEG (B2_ep B2_em) resistor r=250
B2_COMP0 (B2_h0p B2_h0m compvdd logicvdd) COMPLOAD
B2_COMP1 (B2_h1p B2_h1m compvdd logicvdd) COMPLOAD
B2_COMP2 (B2_h2p B2_h2m compvdd logicvdd) COMPLOAD
B2_COMP3 (B2_h3p B2_h3m compvdd logicvdd) COMPLOAD
B2_COMP4 (B2_h4p B2_h4m compvdd logicvdd) COMPLOAD
B2_COMP5 (B2_h5p B2_h5m compvdd logicvdd) COMPLOAD
B2_COMP6 (B2_h6p B2_h6m compvdd logicvdd) COMPLOAD
B2_COMP7 (B2_h7p B2_h7m compvdd logicvdd) COMPLOAD
B3_ck0V (B3_ck0 0) vsource type=pulse val0=0 val1=0.9 delay=1.310181428571429e-10 rise=1e-12 fall=1e-12 width=6.471429999999999e-11 period=5.714288e-10
B3_kb0V (B3_kb0 0) vsource type=pulse val0=0.9 val1=0 delay=1.310181428571429e-10 rise=1e-12 fall=1e-12 width=6.471429999999999e-11 period=5.714288e-10
B3_ck1V (B3_ck1 0) vsource type=pulse val0=0 val1=0.9 delay=2.024467428571429e-10 rise=1e-12 fall=1e-12 width=6.471429999999999e-11 period=5.714288e-10
B3_kb1V (B3_kb1 0) vsource type=pulse val0=0.9 val1=0 delay=2.024467428571429e-10 rise=1e-12 fall=1e-12 width=6.471429999999999e-11 period=5.714288e-10
B3_ck2V (B3_ck2 0) vsource type=pulse val0=0 val1=0.9 delay=2.738753428571429e-10 rise=1e-12 fall=1e-12 width=6.471429999999999e-11 period=5.714288e-10
B3_kb2V (B3_kb2 0) vsource type=pulse val0=0.9 val1=0 delay=2.738753428571429e-10 rise=1e-12 fall=1e-12 width=6.471429999999999e-11 period=5.714288e-10
B3_ck3V (B3_ck3 0) vsource type=pulse val0=0 val1=0.9 delay=3.453039428571429e-10 rise=1e-12 fall=1e-12 width=6.471429999999999e-11 period=5.714288e-10
B3_kb3V (B3_kb3 0) vsource type=pulse val0=0.9 val1=0 delay=3.453039428571429e-10 rise=1e-12 fall=1e-12 width=6.471429999999999e-11 period=5.714288e-10
B3_ck4V (B3_ck4 0) vsource type=pulse val0=0 val1=0.9 delay=4.167325428571429e-10 rise=1e-12 fall=1e-12 width=6.471429999999999e-11 period=5.714288e-10
B3_kb4V (B3_kb4 0) vsource type=pulse val0=0.9 val1=0 delay=4.167325428571429e-10 rise=1e-12 fall=1e-12 width=6.471429999999999e-11 period=5.714288e-10
B3_ck5V (B3_ck5 0) vsource type=pulse val0=0 val1=0.9 delay=4.881611428571428e-10 rise=1e-12 fall=1e-12 width=6.471429999999999e-11 period=5.714288e-10
B3_kb5V (B3_kb5 0) vsource type=pulse val0=0.9 val1=0 delay=4.881611428571428e-10 rise=1e-12 fall=1e-12 width=6.471429999999999e-11 period=5.714288e-10
B3_ck6V (B3_ck6 0) vsource type=pulse val0=0 val1=0.9 delay=5.595897428571428e-10 rise=1e-12 fall=1e-12 width=6.471429999999999e-11 period=5.714288e-10
B3_kb6V (B3_kb6 0) vsource type=pulse val0=0.9 val1=0 delay=5.595897428571428e-10 rise=1e-12 fall=1e-12 width=6.471429999999999e-11 period=5.714288e-10
B3_ck7V (B3_ck7 0) vsource type=pulse val0=0 val1=0.9 delay=6.310183428571428e-10 rise=1e-12 fall=1e-12 width=6.471429999999999e-11 period=5.714288e-10
B3_kb7V (B3_kb7 0) vsource type=pulse val0=0.9 val1=0 delay=6.310183428571428e-10 rise=1e-12 fall=1e-12 width=6.471429999999999e-11 period=5.714288e-10
RB3_Lp (bankvdd B3_fp) resistor r=500
B3_Fp (B3_fp X_h3p B3_ep 0) nmos_lvt l=30n w=2u multi=1 nf=1 sd=100n ad=1.5e-13 as=1.5e-13 pd=4.15u ps=4.15u nrd=0.144730 nrs=0.144730 sa=75.0n sb=75.0n sa1=75.0n sa2=75.0n sa3=75.0n sa4=75.0n sb1=75.0n sb2=75.0n sb3=75.0n spa=100n spa1=100n spa2=100n spa3=100n sap=91.9776n sapb=114.444n spba=115.715n spba1=117.043n dfm_flag=0 _ccoflag=1 _rcoflag=1 _rgflag=1 spmt=1.11111e+15 spomt=0 spomt1=1.11111e+60 spmb=1.11111e+15 spomb=0 spomb1=1.11111e+60
B3_Tp (B3_ep nbias 0 0) nmos_lvt l=60n w=2u multi=1 nf=1 sd=100n ad=1.5e-13 as=1.5e-13 pd=4.15u ps=4.15u nrd=0.144730 nrs=0.144730 sa=75.0n sb=75.0n sa1=75.0n sa2=75.0n sa3=75.0n sa4=75.0n sb1=75.0n sb2=75.0n sb3=75.0n spa=100n spa1=100n spa2=100n spa3=100n sap=91.9776n sapb=120.93n spba=121.82n spba1=124.403n dfm_flag=0 _ccoflag=1 _rcoflag=1 _rgflag=1 spmt=1.11111e+15 spomt=0 spomt1=1.11111e+60 spmb=1.11111e+15 spomb=0 spomb1=1.11111e+60
B3_SN0p (B3_h0p B3_ck0 B3_fp 0) nmos_lvt l=30n w=2u multi=1 nf=1 sd=100n ad=1.5e-13 as=1.5e-13 pd=4.15u ps=4.15u nrd=0.144730 nrs=0.144730 sa=75.0n sb=75.0n sa1=75.0n sa2=75.0n sa3=75.0n sa4=75.0n sb1=75.0n sb2=75.0n sb3=75.0n spa=100n spa1=100n spa2=100n spa3=100n sap=91.9776n sapb=114.444n spba=115.715n spba1=117.043n dfm_flag=0 _ccoflag=1 _rcoflag=1 _rgflag=1 spmt=1.11111e+15 spomt=0 spomt1=1.11111e+60 spmb=1.11111e+15 spomb=0 spomb1=1.11111e+60
B3_SP0p (B3_h0p B3_kb0 B3_fp bankvdd) pmos_lvt l=30n w=2u multi=1 nf=1 sd=100n ad=1.5e-13 as=1.5e-13 pd=4.15u ps=4.15u nrd=0.082877 nrs=0.082877 sa=75.0n sb=75.0n sa1=75.0n sa2=75.0n sa3=75.0n sa4=75.0n sb1=75.0n sb2=75.0n sb3=75.0n spa=100n spa1=100n spa2=100n spa3=100n sap=91.9776n sapb=114.444n spba=115.715n spba1=117.043n dfm_flag=0 _ccoflag=1 _rcoflag=1 _rgflag=1 spmt=1.11111e+15 spomt=0 spomt1=1.11111e+60 spmb=1.11111e+15 spomb=0 spomb1=1.11111e+60
B3_CH0p (B3_h0p 0) capacitor c=2.5e-14
B3_RH0p (B3_h0p B3_fp) resistor r=1T
B3_SN1p (B3_h1p B3_ck1 B3_fp 0) nmos_lvt l=30n w=2u multi=1 nf=1 sd=100n ad=1.5e-13 as=1.5e-13 pd=4.15u ps=4.15u nrd=0.144730 nrs=0.144730 sa=75.0n sb=75.0n sa1=75.0n sa2=75.0n sa3=75.0n sa4=75.0n sb1=75.0n sb2=75.0n sb3=75.0n spa=100n spa1=100n spa2=100n spa3=100n sap=91.9776n sapb=114.444n spba=115.715n spba1=117.043n dfm_flag=0 _ccoflag=1 _rcoflag=1 _rgflag=1 spmt=1.11111e+15 spomt=0 spomt1=1.11111e+60 spmb=1.11111e+15 spomb=0 spomb1=1.11111e+60
B3_SP1p (B3_h1p B3_kb1 B3_fp bankvdd) pmos_lvt l=30n w=2u multi=1 nf=1 sd=100n ad=1.5e-13 as=1.5e-13 pd=4.15u ps=4.15u nrd=0.082877 nrs=0.082877 sa=75.0n sb=75.0n sa1=75.0n sa2=75.0n sa3=75.0n sa4=75.0n sb1=75.0n sb2=75.0n sb3=75.0n spa=100n spa1=100n spa2=100n spa3=100n sap=91.9776n sapb=114.444n spba=115.715n spba1=117.043n dfm_flag=0 _ccoflag=1 _rcoflag=1 _rgflag=1 spmt=1.11111e+15 spomt=0 spomt1=1.11111e+60 spmb=1.11111e+15 spomb=0 spomb1=1.11111e+60
B3_CH1p (B3_h1p 0) capacitor c=2.5e-14
B3_RH1p (B3_h1p B3_fp) resistor r=1T
B3_SN2p (B3_h2p B3_ck2 B3_fp 0) nmos_lvt l=30n w=2u multi=1 nf=1 sd=100n ad=1.5e-13 as=1.5e-13 pd=4.15u ps=4.15u nrd=0.144730 nrs=0.144730 sa=75.0n sb=75.0n sa1=75.0n sa2=75.0n sa3=75.0n sa4=75.0n sb1=75.0n sb2=75.0n sb3=75.0n spa=100n spa1=100n spa2=100n spa3=100n sap=91.9776n sapb=114.444n spba=115.715n spba1=117.043n dfm_flag=0 _ccoflag=1 _rcoflag=1 _rgflag=1 spmt=1.11111e+15 spomt=0 spomt1=1.11111e+60 spmb=1.11111e+15 spomb=0 spomb1=1.11111e+60
B3_SP2p (B3_h2p B3_kb2 B3_fp bankvdd) pmos_lvt l=30n w=2u multi=1 nf=1 sd=100n ad=1.5e-13 as=1.5e-13 pd=4.15u ps=4.15u nrd=0.082877 nrs=0.082877 sa=75.0n sb=75.0n sa1=75.0n sa2=75.0n sa3=75.0n sa4=75.0n sb1=75.0n sb2=75.0n sb3=75.0n spa=100n spa1=100n spa2=100n spa3=100n sap=91.9776n sapb=114.444n spba=115.715n spba1=117.043n dfm_flag=0 _ccoflag=1 _rcoflag=1 _rgflag=1 spmt=1.11111e+15 spomt=0 spomt1=1.11111e+60 spmb=1.11111e+15 spomb=0 spomb1=1.11111e+60
B3_CH2p (B3_h2p 0) capacitor c=2.5e-14
B3_RH2p (B3_h2p B3_fp) resistor r=1T
B3_SN3p (B3_h3p B3_ck3 B3_fp 0) nmos_lvt l=30n w=2u multi=1 nf=1 sd=100n ad=1.5e-13 as=1.5e-13 pd=4.15u ps=4.15u nrd=0.144730 nrs=0.144730 sa=75.0n sb=75.0n sa1=75.0n sa2=75.0n sa3=75.0n sa4=75.0n sb1=75.0n sb2=75.0n sb3=75.0n spa=100n spa1=100n spa2=100n spa3=100n sap=91.9776n sapb=114.444n spba=115.715n spba1=117.043n dfm_flag=0 _ccoflag=1 _rcoflag=1 _rgflag=1 spmt=1.11111e+15 spomt=0 spomt1=1.11111e+60 spmb=1.11111e+15 spomb=0 spomb1=1.11111e+60
B3_SP3p (B3_h3p B3_kb3 B3_fp bankvdd) pmos_lvt l=30n w=2u multi=1 nf=1 sd=100n ad=1.5e-13 as=1.5e-13 pd=4.15u ps=4.15u nrd=0.082877 nrs=0.082877 sa=75.0n sb=75.0n sa1=75.0n sa2=75.0n sa3=75.0n sa4=75.0n sb1=75.0n sb2=75.0n sb3=75.0n spa=100n spa1=100n spa2=100n spa3=100n sap=91.9776n sapb=114.444n spba=115.715n spba1=117.043n dfm_flag=0 _ccoflag=1 _rcoflag=1 _rgflag=1 spmt=1.11111e+15 spomt=0 spomt1=1.11111e+60 spmb=1.11111e+15 spomb=0 spomb1=1.11111e+60
B3_CH3p (B3_h3p 0) capacitor c=2.5e-14
B3_RH3p (B3_h3p B3_fp) resistor r=1T
B3_SN4p (B3_h4p B3_ck4 B3_fp 0) nmos_lvt l=30n w=2u multi=1 nf=1 sd=100n ad=1.5e-13 as=1.5e-13 pd=4.15u ps=4.15u nrd=0.144730 nrs=0.144730 sa=75.0n sb=75.0n sa1=75.0n sa2=75.0n sa3=75.0n sa4=75.0n sb1=75.0n sb2=75.0n sb3=75.0n spa=100n spa1=100n spa2=100n spa3=100n sap=91.9776n sapb=114.444n spba=115.715n spba1=117.043n dfm_flag=0 _ccoflag=1 _rcoflag=1 _rgflag=1 spmt=1.11111e+15 spomt=0 spomt1=1.11111e+60 spmb=1.11111e+15 spomb=0 spomb1=1.11111e+60
B3_SP4p (B3_h4p B3_kb4 B3_fp bankvdd) pmos_lvt l=30n w=2u multi=1 nf=1 sd=100n ad=1.5e-13 as=1.5e-13 pd=4.15u ps=4.15u nrd=0.082877 nrs=0.082877 sa=75.0n sb=75.0n sa1=75.0n sa2=75.0n sa3=75.0n sa4=75.0n sb1=75.0n sb2=75.0n sb3=75.0n spa=100n spa1=100n spa2=100n spa3=100n sap=91.9776n sapb=114.444n spba=115.715n spba1=117.043n dfm_flag=0 _ccoflag=1 _rcoflag=1 _rgflag=1 spmt=1.11111e+15 spomt=0 spomt1=1.11111e+60 spmb=1.11111e+15 spomb=0 spomb1=1.11111e+60
B3_CH4p (B3_h4p 0) capacitor c=2.5e-14
B3_RH4p (B3_h4p B3_fp) resistor r=1T
B3_SN5p (B3_h5p B3_ck5 B3_fp 0) nmos_lvt l=30n w=2u multi=1 nf=1 sd=100n ad=1.5e-13 as=1.5e-13 pd=4.15u ps=4.15u nrd=0.144730 nrs=0.144730 sa=75.0n sb=75.0n sa1=75.0n sa2=75.0n sa3=75.0n sa4=75.0n sb1=75.0n sb2=75.0n sb3=75.0n spa=100n spa1=100n spa2=100n spa3=100n sap=91.9776n sapb=114.444n spba=115.715n spba1=117.043n dfm_flag=0 _ccoflag=1 _rcoflag=1 _rgflag=1 spmt=1.11111e+15 spomt=0 spomt1=1.11111e+60 spmb=1.11111e+15 spomb=0 spomb1=1.11111e+60
B3_SP5p (B3_h5p B3_kb5 B3_fp bankvdd) pmos_lvt l=30n w=2u multi=1 nf=1 sd=100n ad=1.5e-13 as=1.5e-13 pd=4.15u ps=4.15u nrd=0.082877 nrs=0.082877 sa=75.0n sb=75.0n sa1=75.0n sa2=75.0n sa3=75.0n sa4=75.0n sb1=75.0n sb2=75.0n sb3=75.0n spa=100n spa1=100n spa2=100n spa3=100n sap=91.9776n sapb=114.444n spba=115.715n spba1=117.043n dfm_flag=0 _ccoflag=1 _rcoflag=1 _rgflag=1 spmt=1.11111e+15 spomt=0 spomt1=1.11111e+60 spmb=1.11111e+15 spomb=0 spomb1=1.11111e+60
B3_CH5p (B3_h5p 0) capacitor c=2.5e-14
B3_RH5p (B3_h5p B3_fp) resistor r=1T
B3_SN6p (B3_h6p B3_ck6 B3_fp 0) nmos_lvt l=30n w=2u multi=1 nf=1 sd=100n ad=1.5e-13 as=1.5e-13 pd=4.15u ps=4.15u nrd=0.144730 nrs=0.144730 sa=75.0n sb=75.0n sa1=75.0n sa2=75.0n sa3=75.0n sa4=75.0n sb1=75.0n sb2=75.0n sb3=75.0n spa=100n spa1=100n spa2=100n spa3=100n sap=91.9776n sapb=114.444n spba=115.715n spba1=117.043n dfm_flag=0 _ccoflag=1 _rcoflag=1 _rgflag=1 spmt=1.11111e+15 spomt=0 spomt1=1.11111e+60 spmb=1.11111e+15 spomb=0 spomb1=1.11111e+60
B3_SP6p (B3_h6p B3_kb6 B3_fp bankvdd) pmos_lvt l=30n w=2u multi=1 nf=1 sd=100n ad=1.5e-13 as=1.5e-13 pd=4.15u ps=4.15u nrd=0.082877 nrs=0.082877 sa=75.0n sb=75.0n sa1=75.0n sa2=75.0n sa3=75.0n sa4=75.0n sb1=75.0n sb2=75.0n sb3=75.0n spa=100n spa1=100n spa2=100n spa3=100n sap=91.9776n sapb=114.444n spba=115.715n spba1=117.043n dfm_flag=0 _ccoflag=1 _rcoflag=1 _rgflag=1 spmt=1.11111e+15 spomt=0 spomt1=1.11111e+60 spmb=1.11111e+15 spomb=0 spomb1=1.11111e+60
B3_CH6p (B3_h6p 0) capacitor c=2.5e-14
B3_RH6p (B3_h6p B3_fp) resistor r=1T
B3_SN7p (B3_h7p B3_ck7 B3_fp 0) nmos_lvt l=30n w=2u multi=1 nf=1 sd=100n ad=1.5e-13 as=1.5e-13 pd=4.15u ps=4.15u nrd=0.144730 nrs=0.144730 sa=75.0n sb=75.0n sa1=75.0n sa2=75.0n sa3=75.0n sa4=75.0n sb1=75.0n sb2=75.0n sb3=75.0n spa=100n spa1=100n spa2=100n spa3=100n sap=91.9776n sapb=114.444n spba=115.715n spba1=117.043n dfm_flag=0 _ccoflag=1 _rcoflag=1 _rgflag=1 spmt=1.11111e+15 spomt=0 spomt1=1.11111e+60 spmb=1.11111e+15 spomb=0 spomb1=1.11111e+60
B3_SP7p (B3_h7p B3_kb7 B3_fp bankvdd) pmos_lvt l=30n w=2u multi=1 nf=1 sd=100n ad=1.5e-13 as=1.5e-13 pd=4.15u ps=4.15u nrd=0.082877 nrs=0.082877 sa=75.0n sb=75.0n sa1=75.0n sa2=75.0n sa3=75.0n sa4=75.0n sb1=75.0n sb2=75.0n sb3=75.0n spa=100n spa1=100n spa2=100n spa3=100n sap=91.9776n sapb=114.444n spba=115.715n spba1=117.043n dfm_flag=0 _ccoflag=1 _rcoflag=1 _rgflag=1 spmt=1.11111e+15 spomt=0 spomt1=1.11111e+60 spmb=1.11111e+15 spomb=0 spomb1=1.11111e+60
B3_CH7p (B3_h7p 0) capacitor c=2.5e-14
B3_RH7p (B3_h7p B3_fp) resistor r=1T
RB3_Lm (bankvdd B3_fm) resistor r=500
B3_Fm (B3_fm X_h3m B3_em 0) nmos_lvt l=30n w=2u multi=1 nf=1 sd=100n ad=1.5e-13 as=1.5e-13 pd=4.15u ps=4.15u nrd=0.144730 nrs=0.144730 sa=75.0n sb=75.0n sa1=75.0n sa2=75.0n sa3=75.0n sa4=75.0n sb1=75.0n sb2=75.0n sb3=75.0n spa=100n spa1=100n spa2=100n spa3=100n sap=91.9776n sapb=114.444n spba=115.715n spba1=117.043n dfm_flag=0 _ccoflag=1 _rcoflag=1 _rgflag=1 spmt=1.11111e+15 spomt=0 spomt1=1.11111e+60 spmb=1.11111e+15 spomb=0 spomb1=1.11111e+60
B3_Tm (B3_em nbias 0 0) nmos_lvt l=60n w=2u multi=1 nf=1 sd=100n ad=1.5e-13 as=1.5e-13 pd=4.15u ps=4.15u nrd=0.144730 nrs=0.144730 sa=75.0n sb=75.0n sa1=75.0n sa2=75.0n sa3=75.0n sa4=75.0n sb1=75.0n sb2=75.0n sb3=75.0n spa=100n spa1=100n spa2=100n spa3=100n sap=91.9776n sapb=120.93n spba=121.82n spba1=124.403n dfm_flag=0 _ccoflag=1 _rcoflag=1 _rgflag=1 spmt=1.11111e+15 spomt=0 spomt1=1.11111e+60 spmb=1.11111e+15 spomb=0 spomb1=1.11111e+60
B3_SN0m (B3_h0m B3_ck0 B3_fm 0) nmos_lvt l=30n w=2u multi=1 nf=1 sd=100n ad=1.5e-13 as=1.5e-13 pd=4.15u ps=4.15u nrd=0.144730 nrs=0.144730 sa=75.0n sb=75.0n sa1=75.0n sa2=75.0n sa3=75.0n sa4=75.0n sb1=75.0n sb2=75.0n sb3=75.0n spa=100n spa1=100n spa2=100n spa3=100n sap=91.9776n sapb=114.444n spba=115.715n spba1=117.043n dfm_flag=0 _ccoflag=1 _rcoflag=1 _rgflag=1 spmt=1.11111e+15 spomt=0 spomt1=1.11111e+60 spmb=1.11111e+15 spomb=0 spomb1=1.11111e+60
B3_SP0m (B3_h0m B3_kb0 B3_fm bankvdd) pmos_lvt l=30n w=2u multi=1 nf=1 sd=100n ad=1.5e-13 as=1.5e-13 pd=4.15u ps=4.15u nrd=0.082877 nrs=0.082877 sa=75.0n sb=75.0n sa1=75.0n sa2=75.0n sa3=75.0n sa4=75.0n sb1=75.0n sb2=75.0n sb3=75.0n spa=100n spa1=100n spa2=100n spa3=100n sap=91.9776n sapb=114.444n spba=115.715n spba1=117.043n dfm_flag=0 _ccoflag=1 _rcoflag=1 _rgflag=1 spmt=1.11111e+15 spomt=0 spomt1=1.11111e+60 spmb=1.11111e+15 spomb=0 spomb1=1.11111e+60
B3_CH0m (B3_h0m 0) capacitor c=2.5e-14
B3_RH0m (B3_h0m B3_fm) resistor r=1T
B3_SN1m (B3_h1m B3_ck1 B3_fm 0) nmos_lvt l=30n w=2u multi=1 nf=1 sd=100n ad=1.5e-13 as=1.5e-13 pd=4.15u ps=4.15u nrd=0.144730 nrs=0.144730 sa=75.0n sb=75.0n sa1=75.0n sa2=75.0n sa3=75.0n sa4=75.0n sb1=75.0n sb2=75.0n sb3=75.0n spa=100n spa1=100n spa2=100n spa3=100n sap=91.9776n sapb=114.444n spba=115.715n spba1=117.043n dfm_flag=0 _ccoflag=1 _rcoflag=1 _rgflag=1 spmt=1.11111e+15 spomt=0 spomt1=1.11111e+60 spmb=1.11111e+15 spomb=0 spomb1=1.11111e+60
B3_SP1m (B3_h1m B3_kb1 B3_fm bankvdd) pmos_lvt l=30n w=2u multi=1 nf=1 sd=100n ad=1.5e-13 as=1.5e-13 pd=4.15u ps=4.15u nrd=0.082877 nrs=0.082877 sa=75.0n sb=75.0n sa1=75.0n sa2=75.0n sa3=75.0n sa4=75.0n sb1=75.0n sb2=75.0n sb3=75.0n spa=100n spa1=100n spa2=100n spa3=100n sap=91.9776n sapb=114.444n spba=115.715n spba1=117.043n dfm_flag=0 _ccoflag=1 _rcoflag=1 _rgflag=1 spmt=1.11111e+15 spomt=0 spomt1=1.11111e+60 spmb=1.11111e+15 spomb=0 spomb1=1.11111e+60
B3_CH1m (B3_h1m 0) capacitor c=2.5e-14
B3_RH1m (B3_h1m B3_fm) resistor r=1T
B3_SN2m (B3_h2m B3_ck2 B3_fm 0) nmos_lvt l=30n w=2u multi=1 nf=1 sd=100n ad=1.5e-13 as=1.5e-13 pd=4.15u ps=4.15u nrd=0.144730 nrs=0.144730 sa=75.0n sb=75.0n sa1=75.0n sa2=75.0n sa3=75.0n sa4=75.0n sb1=75.0n sb2=75.0n sb3=75.0n spa=100n spa1=100n spa2=100n spa3=100n sap=91.9776n sapb=114.444n spba=115.715n spba1=117.043n dfm_flag=0 _ccoflag=1 _rcoflag=1 _rgflag=1 spmt=1.11111e+15 spomt=0 spomt1=1.11111e+60 spmb=1.11111e+15 spomb=0 spomb1=1.11111e+60
B3_SP2m (B3_h2m B3_kb2 B3_fm bankvdd) pmos_lvt l=30n w=2u multi=1 nf=1 sd=100n ad=1.5e-13 as=1.5e-13 pd=4.15u ps=4.15u nrd=0.082877 nrs=0.082877 sa=75.0n sb=75.0n sa1=75.0n sa2=75.0n sa3=75.0n sa4=75.0n sb1=75.0n sb2=75.0n sb3=75.0n spa=100n spa1=100n spa2=100n spa3=100n sap=91.9776n sapb=114.444n spba=115.715n spba1=117.043n dfm_flag=0 _ccoflag=1 _rcoflag=1 _rgflag=1 spmt=1.11111e+15 spomt=0 spomt1=1.11111e+60 spmb=1.11111e+15 spomb=0 spomb1=1.11111e+60
B3_CH2m (B3_h2m 0) capacitor c=2.5e-14
B3_RH2m (B3_h2m B3_fm) resistor r=1T
B3_SN3m (B3_h3m B3_ck3 B3_fm 0) nmos_lvt l=30n w=2u multi=1 nf=1 sd=100n ad=1.5e-13 as=1.5e-13 pd=4.15u ps=4.15u nrd=0.144730 nrs=0.144730 sa=75.0n sb=75.0n sa1=75.0n sa2=75.0n sa3=75.0n sa4=75.0n sb1=75.0n sb2=75.0n sb3=75.0n spa=100n spa1=100n spa2=100n spa3=100n sap=91.9776n sapb=114.444n spba=115.715n spba1=117.043n dfm_flag=0 _ccoflag=1 _rcoflag=1 _rgflag=1 spmt=1.11111e+15 spomt=0 spomt1=1.11111e+60 spmb=1.11111e+15 spomb=0 spomb1=1.11111e+60
B3_SP3m (B3_h3m B3_kb3 B3_fm bankvdd) pmos_lvt l=30n w=2u multi=1 nf=1 sd=100n ad=1.5e-13 as=1.5e-13 pd=4.15u ps=4.15u nrd=0.082877 nrs=0.082877 sa=75.0n sb=75.0n sa1=75.0n sa2=75.0n sa3=75.0n sa4=75.0n sb1=75.0n sb2=75.0n sb3=75.0n spa=100n spa1=100n spa2=100n spa3=100n sap=91.9776n sapb=114.444n spba=115.715n spba1=117.043n dfm_flag=0 _ccoflag=1 _rcoflag=1 _rgflag=1 spmt=1.11111e+15 spomt=0 spomt1=1.11111e+60 spmb=1.11111e+15 spomb=0 spomb1=1.11111e+60
B3_CH3m (B3_h3m 0) capacitor c=2.5e-14
B3_RH3m (B3_h3m B3_fm) resistor r=1T
B3_SN4m (B3_h4m B3_ck4 B3_fm 0) nmos_lvt l=30n w=2u multi=1 nf=1 sd=100n ad=1.5e-13 as=1.5e-13 pd=4.15u ps=4.15u nrd=0.144730 nrs=0.144730 sa=75.0n sb=75.0n sa1=75.0n sa2=75.0n sa3=75.0n sa4=75.0n sb1=75.0n sb2=75.0n sb3=75.0n spa=100n spa1=100n spa2=100n spa3=100n sap=91.9776n sapb=114.444n spba=115.715n spba1=117.043n dfm_flag=0 _ccoflag=1 _rcoflag=1 _rgflag=1 spmt=1.11111e+15 spomt=0 spomt1=1.11111e+60 spmb=1.11111e+15 spomb=0 spomb1=1.11111e+60
B3_SP4m (B3_h4m B3_kb4 B3_fm bankvdd) pmos_lvt l=30n w=2u multi=1 nf=1 sd=100n ad=1.5e-13 as=1.5e-13 pd=4.15u ps=4.15u nrd=0.082877 nrs=0.082877 sa=75.0n sb=75.0n sa1=75.0n sa2=75.0n sa3=75.0n sa4=75.0n sb1=75.0n sb2=75.0n sb3=75.0n spa=100n spa1=100n spa2=100n spa3=100n sap=91.9776n sapb=114.444n spba=115.715n spba1=117.043n dfm_flag=0 _ccoflag=1 _rcoflag=1 _rgflag=1 spmt=1.11111e+15 spomt=0 spomt1=1.11111e+60 spmb=1.11111e+15 spomb=0 spomb1=1.11111e+60
B3_CH4m (B3_h4m 0) capacitor c=2.5e-14
B3_RH4m (B3_h4m B3_fm) resistor r=1T
B3_SN5m (B3_h5m B3_ck5 B3_fm 0) nmos_lvt l=30n w=2u multi=1 nf=1 sd=100n ad=1.5e-13 as=1.5e-13 pd=4.15u ps=4.15u nrd=0.144730 nrs=0.144730 sa=75.0n sb=75.0n sa1=75.0n sa2=75.0n sa3=75.0n sa4=75.0n sb1=75.0n sb2=75.0n sb3=75.0n spa=100n spa1=100n spa2=100n spa3=100n sap=91.9776n sapb=114.444n spba=115.715n spba1=117.043n dfm_flag=0 _ccoflag=1 _rcoflag=1 _rgflag=1 spmt=1.11111e+15 spomt=0 spomt1=1.11111e+60 spmb=1.11111e+15 spomb=0 spomb1=1.11111e+60
B3_SP5m (B3_h5m B3_kb5 B3_fm bankvdd) pmos_lvt l=30n w=2u multi=1 nf=1 sd=100n ad=1.5e-13 as=1.5e-13 pd=4.15u ps=4.15u nrd=0.082877 nrs=0.082877 sa=75.0n sb=75.0n sa1=75.0n sa2=75.0n sa3=75.0n sa4=75.0n sb1=75.0n sb2=75.0n sb3=75.0n spa=100n spa1=100n spa2=100n spa3=100n sap=91.9776n sapb=114.444n spba=115.715n spba1=117.043n dfm_flag=0 _ccoflag=1 _rcoflag=1 _rgflag=1 spmt=1.11111e+15 spomt=0 spomt1=1.11111e+60 spmb=1.11111e+15 spomb=0 spomb1=1.11111e+60
B3_CH5m (B3_h5m 0) capacitor c=2.5e-14
B3_RH5m (B3_h5m B3_fm) resistor r=1T
B3_SN6m (B3_h6m B3_ck6 B3_fm 0) nmos_lvt l=30n w=2u multi=1 nf=1 sd=100n ad=1.5e-13 as=1.5e-13 pd=4.15u ps=4.15u nrd=0.144730 nrs=0.144730 sa=75.0n sb=75.0n sa1=75.0n sa2=75.0n sa3=75.0n sa4=75.0n sb1=75.0n sb2=75.0n sb3=75.0n spa=100n spa1=100n spa2=100n spa3=100n sap=91.9776n sapb=114.444n spba=115.715n spba1=117.043n dfm_flag=0 _ccoflag=1 _rcoflag=1 _rgflag=1 spmt=1.11111e+15 spomt=0 spomt1=1.11111e+60 spmb=1.11111e+15 spomb=0 spomb1=1.11111e+60
B3_SP6m (B3_h6m B3_kb6 B3_fm bankvdd) pmos_lvt l=30n w=2u multi=1 nf=1 sd=100n ad=1.5e-13 as=1.5e-13 pd=4.15u ps=4.15u nrd=0.082877 nrs=0.082877 sa=75.0n sb=75.0n sa1=75.0n sa2=75.0n sa3=75.0n sa4=75.0n sb1=75.0n sb2=75.0n sb3=75.0n spa=100n spa1=100n spa2=100n spa3=100n sap=91.9776n sapb=114.444n spba=115.715n spba1=117.043n dfm_flag=0 _ccoflag=1 _rcoflag=1 _rgflag=1 spmt=1.11111e+15 spomt=0 spomt1=1.11111e+60 spmb=1.11111e+15 spomb=0 spomb1=1.11111e+60
B3_CH6m (B3_h6m 0) capacitor c=2.5e-14
B3_RH6m (B3_h6m B3_fm) resistor r=1T
B3_SN7m (B3_h7m B3_ck7 B3_fm 0) nmos_lvt l=30n w=2u multi=1 nf=1 sd=100n ad=1.5e-13 as=1.5e-13 pd=4.15u ps=4.15u nrd=0.144730 nrs=0.144730 sa=75.0n sb=75.0n sa1=75.0n sa2=75.0n sa3=75.0n sa4=75.0n sb1=75.0n sb2=75.0n sb3=75.0n spa=100n spa1=100n spa2=100n spa3=100n sap=91.9776n sapb=114.444n spba=115.715n spba1=117.043n dfm_flag=0 _ccoflag=1 _rcoflag=1 _rgflag=1 spmt=1.11111e+15 spomt=0 spomt1=1.11111e+60 spmb=1.11111e+15 spomb=0 spomb1=1.11111e+60
B3_SP7m (B3_h7m B3_kb7 B3_fm bankvdd) pmos_lvt l=30n w=2u multi=1 nf=1 sd=100n ad=1.5e-13 as=1.5e-13 pd=4.15u ps=4.15u nrd=0.082877 nrs=0.082877 sa=75.0n sb=75.0n sa1=75.0n sa2=75.0n sa3=75.0n sa4=75.0n sb1=75.0n sb2=75.0n sb3=75.0n spa=100n spa1=100n spa2=100n spa3=100n sap=91.9776n sapb=114.444n spba=115.715n spba1=117.043n dfm_flag=0 _ccoflag=1 _rcoflag=1 _rgflag=1 spmt=1.11111e+15 spomt=0 spomt1=1.11111e+60 spmb=1.11111e+15 spomb=0 spomb1=1.11111e+60
B3_CH7m (B3_h7m 0) capacitor c=2.5e-14
B3_RH7m (B3_h7m B3_fm) resistor r=1T
B3_RDEG (B3_ep B3_em) resistor r=250
B3_COMP0 (B3_h0p B3_h0m compvdd logicvdd) COMPLOAD
B3_COMP1 (B3_h1p B3_h1m compvdd logicvdd) COMPLOAD
B3_COMP2 (B3_h2p B3_h2m compvdd logicvdd) COMPLOAD
B3_COMP3 (B3_h3p B3_h3m compvdd logicvdd) COMPLOAD
B3_COMP4 (B3_h4p B3_h4m compvdd logicvdd) COMPLOAD
B3_COMP5 (B3_h5p B3_h5m compvdd logicvdd) COMPLOAD
B3_COMP6 (B3_h6p B3_h6m compvdd logicvdd) COMPLOAD
B3_COMP7 (B3_h7p B3_h7m compvdd logicvdd) COMPLOAD
B4_ck0V (B4_ck0 0) vsource type=pulse val0=0 val1=0.9 delay=1.399461428571429e-10 rise=1e-12 fall=1e-12 width=6.471429999999999e-11 period=5.714288e-10
B4_kb0V (B4_kb0 0) vsource type=pulse val0=0.9 val1=0 delay=1.399461428571429e-10 rise=1e-12 fall=1e-12 width=6.471429999999999e-11 period=5.714288e-10
B4_ck1V (B4_ck1 0) vsource type=pulse val0=0 val1=0.9 delay=2.113747428571429e-10 rise=1e-12 fall=1e-12 width=6.471429999999999e-11 period=5.714288e-10
B4_kb1V (B4_kb1 0) vsource type=pulse val0=0.9 val1=0 delay=2.113747428571429e-10 rise=1e-12 fall=1e-12 width=6.471429999999999e-11 period=5.714288e-10
B4_ck2V (B4_ck2 0) vsource type=pulse val0=0 val1=0.9 delay=2.828033428571429e-10 rise=1e-12 fall=1e-12 width=6.471429999999999e-11 period=5.714288e-10
B4_kb2V (B4_kb2 0) vsource type=pulse val0=0.9 val1=0 delay=2.828033428571429e-10 rise=1e-12 fall=1e-12 width=6.471429999999999e-11 period=5.714288e-10
B4_ck3V (B4_ck3 0) vsource type=pulse val0=0 val1=0.9 delay=3.542319428571429e-10 rise=1e-12 fall=1e-12 width=6.471429999999999e-11 period=5.714288e-10
B4_kb3V (B4_kb3 0) vsource type=pulse val0=0.9 val1=0 delay=3.542319428571429e-10 rise=1e-12 fall=1e-12 width=6.471429999999999e-11 period=5.714288e-10
B4_ck4V (B4_ck4 0) vsource type=pulse val0=0 val1=0.9 delay=4.256605428571429e-10 rise=1e-12 fall=1e-12 width=6.471429999999999e-11 period=5.714288e-10
B4_kb4V (B4_kb4 0) vsource type=pulse val0=0.9 val1=0 delay=4.256605428571429e-10 rise=1e-12 fall=1e-12 width=6.471429999999999e-11 period=5.714288e-10
B4_ck5V (B4_ck5 0) vsource type=pulse val0=0 val1=0.9 delay=4.970891428571428e-10 rise=1e-12 fall=1e-12 width=6.471429999999999e-11 period=5.714288e-10
B4_kb5V (B4_kb5 0) vsource type=pulse val0=0.9 val1=0 delay=4.970891428571428e-10 rise=1e-12 fall=1e-12 width=6.471429999999999e-11 period=5.714288e-10
B4_ck6V (B4_ck6 0) vsource type=pulse val0=0 val1=0.9 delay=5.685177428571428e-10 rise=1e-12 fall=1e-12 width=6.471429999999999e-11 period=5.714288e-10
B4_kb6V (B4_kb6 0) vsource type=pulse val0=0.9 val1=0 delay=5.685177428571428e-10 rise=1e-12 fall=1e-12 width=6.471429999999999e-11 period=5.714288e-10
B4_ck7V (B4_ck7 0) vsource type=pulse val0=0 val1=0.9 delay=6.399463428571428e-10 rise=1e-12 fall=1e-12 width=6.471429999999999e-11 period=5.714288e-10
B4_kb7V (B4_kb7 0) vsource type=pulse val0=0.9 val1=0 delay=6.399463428571428e-10 rise=1e-12 fall=1e-12 width=6.471429999999999e-11 period=5.714288e-10
RB4_Lp (bankvdd B4_fp) resistor r=500
B4_Fp (B4_fp X_h4p B4_ep 0) nmos_lvt l=30n w=2u multi=1 nf=1 sd=100n ad=1.5e-13 as=1.5e-13 pd=4.15u ps=4.15u nrd=0.144730 nrs=0.144730 sa=75.0n sb=75.0n sa1=75.0n sa2=75.0n sa3=75.0n sa4=75.0n sb1=75.0n sb2=75.0n sb3=75.0n spa=100n spa1=100n spa2=100n spa3=100n sap=91.9776n sapb=114.444n spba=115.715n spba1=117.043n dfm_flag=0 _ccoflag=1 _rcoflag=1 _rgflag=1 spmt=1.11111e+15 spomt=0 spomt1=1.11111e+60 spmb=1.11111e+15 spomb=0 spomb1=1.11111e+60
B4_Tp (B4_ep nbias 0 0) nmos_lvt l=60n w=2u multi=1 nf=1 sd=100n ad=1.5e-13 as=1.5e-13 pd=4.15u ps=4.15u nrd=0.144730 nrs=0.144730 sa=75.0n sb=75.0n sa1=75.0n sa2=75.0n sa3=75.0n sa4=75.0n sb1=75.0n sb2=75.0n sb3=75.0n spa=100n spa1=100n spa2=100n spa3=100n sap=91.9776n sapb=120.93n spba=121.82n spba1=124.403n dfm_flag=0 _ccoflag=1 _rcoflag=1 _rgflag=1 spmt=1.11111e+15 spomt=0 spomt1=1.11111e+60 spmb=1.11111e+15 spomb=0 spomb1=1.11111e+60
B4_SN0p (B4_h0p B4_ck0 B4_fp 0) nmos_lvt l=30n w=2u multi=1 nf=1 sd=100n ad=1.5e-13 as=1.5e-13 pd=4.15u ps=4.15u nrd=0.144730 nrs=0.144730 sa=75.0n sb=75.0n sa1=75.0n sa2=75.0n sa3=75.0n sa4=75.0n sb1=75.0n sb2=75.0n sb3=75.0n spa=100n spa1=100n spa2=100n spa3=100n sap=91.9776n sapb=114.444n spba=115.715n spba1=117.043n dfm_flag=0 _ccoflag=1 _rcoflag=1 _rgflag=1 spmt=1.11111e+15 spomt=0 spomt1=1.11111e+60 spmb=1.11111e+15 spomb=0 spomb1=1.11111e+60
B4_SP0p (B4_h0p B4_kb0 B4_fp bankvdd) pmos_lvt l=30n w=2u multi=1 nf=1 sd=100n ad=1.5e-13 as=1.5e-13 pd=4.15u ps=4.15u nrd=0.082877 nrs=0.082877 sa=75.0n sb=75.0n sa1=75.0n sa2=75.0n sa3=75.0n sa4=75.0n sb1=75.0n sb2=75.0n sb3=75.0n spa=100n spa1=100n spa2=100n spa3=100n sap=91.9776n sapb=114.444n spba=115.715n spba1=117.043n dfm_flag=0 _ccoflag=1 _rcoflag=1 _rgflag=1 spmt=1.11111e+15 spomt=0 spomt1=1.11111e+60 spmb=1.11111e+15 spomb=0 spomb1=1.11111e+60
B4_CH0p (B4_h0p 0) capacitor c=2.5e-14
B4_RH0p (B4_h0p B4_fp) resistor r=1T
B4_SN1p (B4_h1p B4_ck1 B4_fp 0) nmos_lvt l=30n w=2u multi=1 nf=1 sd=100n ad=1.5e-13 as=1.5e-13 pd=4.15u ps=4.15u nrd=0.144730 nrs=0.144730 sa=75.0n sb=75.0n sa1=75.0n sa2=75.0n sa3=75.0n sa4=75.0n sb1=75.0n sb2=75.0n sb3=75.0n spa=100n spa1=100n spa2=100n spa3=100n sap=91.9776n sapb=114.444n spba=115.715n spba1=117.043n dfm_flag=0 _ccoflag=1 _rcoflag=1 _rgflag=1 spmt=1.11111e+15 spomt=0 spomt1=1.11111e+60 spmb=1.11111e+15 spomb=0 spomb1=1.11111e+60
B4_SP1p (B4_h1p B4_kb1 B4_fp bankvdd) pmos_lvt l=30n w=2u multi=1 nf=1 sd=100n ad=1.5e-13 as=1.5e-13 pd=4.15u ps=4.15u nrd=0.082877 nrs=0.082877 sa=75.0n sb=75.0n sa1=75.0n sa2=75.0n sa3=75.0n sa4=75.0n sb1=75.0n sb2=75.0n sb3=75.0n spa=100n spa1=100n spa2=100n spa3=100n sap=91.9776n sapb=114.444n spba=115.715n spba1=117.043n dfm_flag=0 _ccoflag=1 _rcoflag=1 _rgflag=1 spmt=1.11111e+15 spomt=0 spomt1=1.11111e+60 spmb=1.11111e+15 spomb=0 spomb1=1.11111e+60
B4_CH1p (B4_h1p 0) capacitor c=2.5e-14
B4_RH1p (B4_h1p B4_fp) resistor r=1T
B4_SN2p (B4_h2p B4_ck2 B4_fp 0) nmos_lvt l=30n w=2u multi=1 nf=1 sd=100n ad=1.5e-13 as=1.5e-13 pd=4.15u ps=4.15u nrd=0.144730 nrs=0.144730 sa=75.0n sb=75.0n sa1=75.0n sa2=75.0n sa3=75.0n sa4=75.0n sb1=75.0n sb2=75.0n sb3=75.0n spa=100n spa1=100n spa2=100n spa3=100n sap=91.9776n sapb=114.444n spba=115.715n spba1=117.043n dfm_flag=0 _ccoflag=1 _rcoflag=1 _rgflag=1 spmt=1.11111e+15 spomt=0 spomt1=1.11111e+60 spmb=1.11111e+15 spomb=0 spomb1=1.11111e+60
B4_SP2p (B4_h2p B4_kb2 B4_fp bankvdd) pmos_lvt l=30n w=2u multi=1 nf=1 sd=100n ad=1.5e-13 as=1.5e-13 pd=4.15u ps=4.15u nrd=0.082877 nrs=0.082877 sa=75.0n sb=75.0n sa1=75.0n sa2=75.0n sa3=75.0n sa4=75.0n sb1=75.0n sb2=75.0n sb3=75.0n spa=100n spa1=100n spa2=100n spa3=100n sap=91.9776n sapb=114.444n spba=115.715n spba1=117.043n dfm_flag=0 _ccoflag=1 _rcoflag=1 _rgflag=1 spmt=1.11111e+15 spomt=0 spomt1=1.11111e+60 spmb=1.11111e+15 spomb=0 spomb1=1.11111e+60
B4_CH2p (B4_h2p 0) capacitor c=2.5e-14
B4_RH2p (B4_h2p B4_fp) resistor r=1T
B4_SN3p (B4_h3p B4_ck3 B4_fp 0) nmos_lvt l=30n w=2u multi=1 nf=1 sd=100n ad=1.5e-13 as=1.5e-13 pd=4.15u ps=4.15u nrd=0.144730 nrs=0.144730 sa=75.0n sb=75.0n sa1=75.0n sa2=75.0n sa3=75.0n sa4=75.0n sb1=75.0n sb2=75.0n sb3=75.0n spa=100n spa1=100n spa2=100n spa3=100n sap=91.9776n sapb=114.444n spba=115.715n spba1=117.043n dfm_flag=0 _ccoflag=1 _rcoflag=1 _rgflag=1 spmt=1.11111e+15 spomt=0 spomt1=1.11111e+60 spmb=1.11111e+15 spomb=0 spomb1=1.11111e+60
B4_SP3p (B4_h3p B4_kb3 B4_fp bankvdd) pmos_lvt l=30n w=2u multi=1 nf=1 sd=100n ad=1.5e-13 as=1.5e-13 pd=4.15u ps=4.15u nrd=0.082877 nrs=0.082877 sa=75.0n sb=75.0n sa1=75.0n sa2=75.0n sa3=75.0n sa4=75.0n sb1=75.0n sb2=75.0n sb3=75.0n spa=100n spa1=100n spa2=100n spa3=100n sap=91.9776n sapb=114.444n spba=115.715n spba1=117.043n dfm_flag=0 _ccoflag=1 _rcoflag=1 _rgflag=1 spmt=1.11111e+15 spomt=0 spomt1=1.11111e+60 spmb=1.11111e+15 spomb=0 spomb1=1.11111e+60
B4_CH3p (B4_h3p 0) capacitor c=2.5e-14
B4_RH3p (B4_h3p B4_fp) resistor r=1T
B4_SN4p (B4_h4p B4_ck4 B4_fp 0) nmos_lvt l=30n w=2u multi=1 nf=1 sd=100n ad=1.5e-13 as=1.5e-13 pd=4.15u ps=4.15u nrd=0.144730 nrs=0.144730 sa=75.0n sb=75.0n sa1=75.0n sa2=75.0n sa3=75.0n sa4=75.0n sb1=75.0n sb2=75.0n sb3=75.0n spa=100n spa1=100n spa2=100n spa3=100n sap=91.9776n sapb=114.444n spba=115.715n spba1=117.043n dfm_flag=0 _ccoflag=1 _rcoflag=1 _rgflag=1 spmt=1.11111e+15 spomt=0 spomt1=1.11111e+60 spmb=1.11111e+15 spomb=0 spomb1=1.11111e+60
B4_SP4p (B4_h4p B4_kb4 B4_fp bankvdd) pmos_lvt l=30n w=2u multi=1 nf=1 sd=100n ad=1.5e-13 as=1.5e-13 pd=4.15u ps=4.15u nrd=0.082877 nrs=0.082877 sa=75.0n sb=75.0n sa1=75.0n sa2=75.0n sa3=75.0n sa4=75.0n sb1=75.0n sb2=75.0n sb3=75.0n spa=100n spa1=100n spa2=100n spa3=100n sap=91.9776n sapb=114.444n spba=115.715n spba1=117.043n dfm_flag=0 _ccoflag=1 _rcoflag=1 _rgflag=1 spmt=1.11111e+15 spomt=0 spomt1=1.11111e+60 spmb=1.11111e+15 spomb=0 spomb1=1.11111e+60
B4_CH4p (B4_h4p 0) capacitor c=2.5e-14
B4_RH4p (B4_h4p B4_fp) resistor r=1T
B4_SN5p (B4_h5p B4_ck5 B4_fp 0) nmos_lvt l=30n w=2u multi=1 nf=1 sd=100n ad=1.5e-13 as=1.5e-13 pd=4.15u ps=4.15u nrd=0.144730 nrs=0.144730 sa=75.0n sb=75.0n sa1=75.0n sa2=75.0n sa3=75.0n sa4=75.0n sb1=75.0n sb2=75.0n sb3=75.0n spa=100n spa1=100n spa2=100n spa3=100n sap=91.9776n sapb=114.444n spba=115.715n spba1=117.043n dfm_flag=0 _ccoflag=1 _rcoflag=1 _rgflag=1 spmt=1.11111e+15 spomt=0 spomt1=1.11111e+60 spmb=1.11111e+15 spomb=0 spomb1=1.11111e+60
B4_SP5p (B4_h5p B4_kb5 B4_fp bankvdd) pmos_lvt l=30n w=2u multi=1 nf=1 sd=100n ad=1.5e-13 as=1.5e-13 pd=4.15u ps=4.15u nrd=0.082877 nrs=0.082877 sa=75.0n sb=75.0n sa1=75.0n sa2=75.0n sa3=75.0n sa4=75.0n sb1=75.0n sb2=75.0n sb3=75.0n spa=100n spa1=100n spa2=100n spa3=100n sap=91.9776n sapb=114.444n spba=115.715n spba1=117.043n dfm_flag=0 _ccoflag=1 _rcoflag=1 _rgflag=1 spmt=1.11111e+15 spomt=0 spomt1=1.11111e+60 spmb=1.11111e+15 spomb=0 spomb1=1.11111e+60
B4_CH5p (B4_h5p 0) capacitor c=2.5e-14
B4_RH5p (B4_h5p B4_fp) resistor r=1T
B4_SN6p (B4_h6p B4_ck6 B4_fp 0) nmos_lvt l=30n w=2u multi=1 nf=1 sd=100n ad=1.5e-13 as=1.5e-13 pd=4.15u ps=4.15u nrd=0.144730 nrs=0.144730 sa=75.0n sb=75.0n sa1=75.0n sa2=75.0n sa3=75.0n sa4=75.0n sb1=75.0n sb2=75.0n sb3=75.0n spa=100n spa1=100n spa2=100n spa3=100n sap=91.9776n sapb=114.444n spba=115.715n spba1=117.043n dfm_flag=0 _ccoflag=1 _rcoflag=1 _rgflag=1 spmt=1.11111e+15 spomt=0 spomt1=1.11111e+60 spmb=1.11111e+15 spomb=0 spomb1=1.11111e+60
B4_SP6p (B4_h6p B4_kb6 B4_fp bankvdd) pmos_lvt l=30n w=2u multi=1 nf=1 sd=100n ad=1.5e-13 as=1.5e-13 pd=4.15u ps=4.15u nrd=0.082877 nrs=0.082877 sa=75.0n sb=75.0n sa1=75.0n sa2=75.0n sa3=75.0n sa4=75.0n sb1=75.0n sb2=75.0n sb3=75.0n spa=100n spa1=100n spa2=100n spa3=100n sap=91.9776n sapb=114.444n spba=115.715n spba1=117.043n dfm_flag=0 _ccoflag=1 _rcoflag=1 _rgflag=1 spmt=1.11111e+15 spomt=0 spomt1=1.11111e+60 spmb=1.11111e+15 spomb=0 spomb1=1.11111e+60
B4_CH6p (B4_h6p 0) capacitor c=2.5e-14
B4_RH6p (B4_h6p B4_fp) resistor r=1T
B4_SN7p (B4_h7p B4_ck7 B4_fp 0) nmos_lvt l=30n w=2u multi=1 nf=1 sd=100n ad=1.5e-13 as=1.5e-13 pd=4.15u ps=4.15u nrd=0.144730 nrs=0.144730 sa=75.0n sb=75.0n sa1=75.0n sa2=75.0n sa3=75.0n sa4=75.0n sb1=75.0n sb2=75.0n sb3=75.0n spa=100n spa1=100n spa2=100n spa3=100n sap=91.9776n sapb=114.444n spba=115.715n spba1=117.043n dfm_flag=0 _ccoflag=1 _rcoflag=1 _rgflag=1 spmt=1.11111e+15 spomt=0 spomt1=1.11111e+60 spmb=1.11111e+15 spomb=0 spomb1=1.11111e+60
B4_SP7p (B4_h7p B4_kb7 B4_fp bankvdd) pmos_lvt l=30n w=2u multi=1 nf=1 sd=100n ad=1.5e-13 as=1.5e-13 pd=4.15u ps=4.15u nrd=0.082877 nrs=0.082877 sa=75.0n sb=75.0n sa1=75.0n sa2=75.0n sa3=75.0n sa4=75.0n sb1=75.0n sb2=75.0n sb3=75.0n spa=100n spa1=100n spa2=100n spa3=100n sap=91.9776n sapb=114.444n spba=115.715n spba1=117.043n dfm_flag=0 _ccoflag=1 _rcoflag=1 _rgflag=1 spmt=1.11111e+15 spomt=0 spomt1=1.11111e+60 spmb=1.11111e+15 spomb=0 spomb1=1.11111e+60
B4_CH7p (B4_h7p 0) capacitor c=2.5e-14
B4_RH7p (B4_h7p B4_fp) resistor r=1T
RB4_Lm (bankvdd B4_fm) resistor r=500
B4_Fm (B4_fm X_h4m B4_em 0) nmos_lvt l=30n w=2u multi=1 nf=1 sd=100n ad=1.5e-13 as=1.5e-13 pd=4.15u ps=4.15u nrd=0.144730 nrs=0.144730 sa=75.0n sb=75.0n sa1=75.0n sa2=75.0n sa3=75.0n sa4=75.0n sb1=75.0n sb2=75.0n sb3=75.0n spa=100n spa1=100n spa2=100n spa3=100n sap=91.9776n sapb=114.444n spba=115.715n spba1=117.043n dfm_flag=0 _ccoflag=1 _rcoflag=1 _rgflag=1 spmt=1.11111e+15 spomt=0 spomt1=1.11111e+60 spmb=1.11111e+15 spomb=0 spomb1=1.11111e+60
B4_Tm (B4_em nbias 0 0) nmos_lvt l=60n w=2u multi=1 nf=1 sd=100n ad=1.5e-13 as=1.5e-13 pd=4.15u ps=4.15u nrd=0.144730 nrs=0.144730 sa=75.0n sb=75.0n sa1=75.0n sa2=75.0n sa3=75.0n sa4=75.0n sb1=75.0n sb2=75.0n sb3=75.0n spa=100n spa1=100n spa2=100n spa3=100n sap=91.9776n sapb=120.93n spba=121.82n spba1=124.403n dfm_flag=0 _ccoflag=1 _rcoflag=1 _rgflag=1 spmt=1.11111e+15 spomt=0 spomt1=1.11111e+60 spmb=1.11111e+15 spomb=0 spomb1=1.11111e+60
B4_SN0m (B4_h0m B4_ck0 B4_fm 0) nmos_lvt l=30n w=2u multi=1 nf=1 sd=100n ad=1.5e-13 as=1.5e-13 pd=4.15u ps=4.15u nrd=0.144730 nrs=0.144730 sa=75.0n sb=75.0n sa1=75.0n sa2=75.0n sa3=75.0n sa4=75.0n sb1=75.0n sb2=75.0n sb3=75.0n spa=100n spa1=100n spa2=100n spa3=100n sap=91.9776n sapb=114.444n spba=115.715n spba1=117.043n dfm_flag=0 _ccoflag=1 _rcoflag=1 _rgflag=1 spmt=1.11111e+15 spomt=0 spomt1=1.11111e+60 spmb=1.11111e+15 spomb=0 spomb1=1.11111e+60
B4_SP0m (B4_h0m B4_kb0 B4_fm bankvdd) pmos_lvt l=30n w=2u multi=1 nf=1 sd=100n ad=1.5e-13 as=1.5e-13 pd=4.15u ps=4.15u nrd=0.082877 nrs=0.082877 sa=75.0n sb=75.0n sa1=75.0n sa2=75.0n sa3=75.0n sa4=75.0n sb1=75.0n sb2=75.0n sb3=75.0n spa=100n spa1=100n spa2=100n spa3=100n sap=91.9776n sapb=114.444n spba=115.715n spba1=117.043n dfm_flag=0 _ccoflag=1 _rcoflag=1 _rgflag=1 spmt=1.11111e+15 spomt=0 spomt1=1.11111e+60 spmb=1.11111e+15 spomb=0 spomb1=1.11111e+60
B4_CH0m (B4_h0m 0) capacitor c=2.5e-14
B4_RH0m (B4_h0m B4_fm) resistor r=1T
B4_SN1m (B4_h1m B4_ck1 B4_fm 0) nmos_lvt l=30n w=2u multi=1 nf=1 sd=100n ad=1.5e-13 as=1.5e-13 pd=4.15u ps=4.15u nrd=0.144730 nrs=0.144730 sa=75.0n sb=75.0n sa1=75.0n sa2=75.0n sa3=75.0n sa4=75.0n sb1=75.0n sb2=75.0n sb3=75.0n spa=100n spa1=100n spa2=100n spa3=100n sap=91.9776n sapb=114.444n spba=115.715n spba1=117.043n dfm_flag=0 _ccoflag=1 _rcoflag=1 _rgflag=1 spmt=1.11111e+15 spomt=0 spomt1=1.11111e+60 spmb=1.11111e+15 spomb=0 spomb1=1.11111e+60
B4_SP1m (B4_h1m B4_kb1 B4_fm bankvdd) pmos_lvt l=30n w=2u multi=1 nf=1 sd=100n ad=1.5e-13 as=1.5e-13 pd=4.15u ps=4.15u nrd=0.082877 nrs=0.082877 sa=75.0n sb=75.0n sa1=75.0n sa2=75.0n sa3=75.0n sa4=75.0n sb1=75.0n sb2=75.0n sb3=75.0n spa=100n spa1=100n spa2=100n spa3=100n sap=91.9776n sapb=114.444n spba=115.715n spba1=117.043n dfm_flag=0 _ccoflag=1 _rcoflag=1 _rgflag=1 spmt=1.11111e+15 spomt=0 spomt1=1.11111e+60 spmb=1.11111e+15 spomb=0 spomb1=1.11111e+60
B4_CH1m (B4_h1m 0) capacitor c=2.5e-14
B4_RH1m (B4_h1m B4_fm) resistor r=1T
B4_SN2m (B4_h2m B4_ck2 B4_fm 0) nmos_lvt l=30n w=2u multi=1 nf=1 sd=100n ad=1.5e-13 as=1.5e-13 pd=4.15u ps=4.15u nrd=0.144730 nrs=0.144730 sa=75.0n sb=75.0n sa1=75.0n sa2=75.0n sa3=75.0n sa4=75.0n sb1=75.0n sb2=75.0n sb3=75.0n spa=100n spa1=100n spa2=100n spa3=100n sap=91.9776n sapb=114.444n spba=115.715n spba1=117.043n dfm_flag=0 _ccoflag=1 _rcoflag=1 _rgflag=1 spmt=1.11111e+15 spomt=0 spomt1=1.11111e+60 spmb=1.11111e+15 spomb=0 spomb1=1.11111e+60
B4_SP2m (B4_h2m B4_kb2 B4_fm bankvdd) pmos_lvt l=30n w=2u multi=1 nf=1 sd=100n ad=1.5e-13 as=1.5e-13 pd=4.15u ps=4.15u nrd=0.082877 nrs=0.082877 sa=75.0n sb=75.0n sa1=75.0n sa2=75.0n sa3=75.0n sa4=75.0n sb1=75.0n sb2=75.0n sb3=75.0n spa=100n spa1=100n spa2=100n spa3=100n sap=91.9776n sapb=114.444n spba=115.715n spba1=117.043n dfm_flag=0 _ccoflag=1 _rcoflag=1 _rgflag=1 spmt=1.11111e+15 spomt=0 spomt1=1.11111e+60 spmb=1.11111e+15 spomb=0 spomb1=1.11111e+60
B4_CH2m (B4_h2m 0) capacitor c=2.5e-14
B4_RH2m (B4_h2m B4_fm) resistor r=1T
B4_SN3m (B4_h3m B4_ck3 B4_fm 0) nmos_lvt l=30n w=2u multi=1 nf=1 sd=100n ad=1.5e-13 as=1.5e-13 pd=4.15u ps=4.15u nrd=0.144730 nrs=0.144730 sa=75.0n sb=75.0n sa1=75.0n sa2=75.0n sa3=75.0n sa4=75.0n sb1=75.0n sb2=75.0n sb3=75.0n spa=100n spa1=100n spa2=100n spa3=100n sap=91.9776n sapb=114.444n spba=115.715n spba1=117.043n dfm_flag=0 _ccoflag=1 _rcoflag=1 _rgflag=1 spmt=1.11111e+15 spomt=0 spomt1=1.11111e+60 spmb=1.11111e+15 spomb=0 spomb1=1.11111e+60
B4_SP3m (B4_h3m B4_kb3 B4_fm bankvdd) pmos_lvt l=30n w=2u multi=1 nf=1 sd=100n ad=1.5e-13 as=1.5e-13 pd=4.15u ps=4.15u nrd=0.082877 nrs=0.082877 sa=75.0n sb=75.0n sa1=75.0n sa2=75.0n sa3=75.0n sa4=75.0n sb1=75.0n sb2=75.0n sb3=75.0n spa=100n spa1=100n spa2=100n spa3=100n sap=91.9776n sapb=114.444n spba=115.715n spba1=117.043n dfm_flag=0 _ccoflag=1 _rcoflag=1 _rgflag=1 spmt=1.11111e+15 spomt=0 spomt1=1.11111e+60 spmb=1.11111e+15 spomb=0 spomb1=1.11111e+60
B4_CH3m (B4_h3m 0) capacitor c=2.5e-14
B4_RH3m (B4_h3m B4_fm) resistor r=1T
B4_SN4m (B4_h4m B4_ck4 B4_fm 0) nmos_lvt l=30n w=2u multi=1 nf=1 sd=100n ad=1.5e-13 as=1.5e-13 pd=4.15u ps=4.15u nrd=0.144730 nrs=0.144730 sa=75.0n sb=75.0n sa1=75.0n sa2=75.0n sa3=75.0n sa4=75.0n sb1=75.0n sb2=75.0n sb3=75.0n spa=100n spa1=100n spa2=100n spa3=100n sap=91.9776n sapb=114.444n spba=115.715n spba1=117.043n dfm_flag=0 _ccoflag=1 _rcoflag=1 _rgflag=1 spmt=1.11111e+15 spomt=0 spomt1=1.11111e+60 spmb=1.11111e+15 spomb=0 spomb1=1.11111e+60
B4_SP4m (B4_h4m B4_kb4 B4_fm bankvdd) pmos_lvt l=30n w=2u multi=1 nf=1 sd=100n ad=1.5e-13 as=1.5e-13 pd=4.15u ps=4.15u nrd=0.082877 nrs=0.082877 sa=75.0n sb=75.0n sa1=75.0n sa2=75.0n sa3=75.0n sa4=75.0n sb1=75.0n sb2=75.0n sb3=75.0n spa=100n spa1=100n spa2=100n spa3=100n sap=91.9776n sapb=114.444n spba=115.715n spba1=117.043n dfm_flag=0 _ccoflag=1 _rcoflag=1 _rgflag=1 spmt=1.11111e+15 spomt=0 spomt1=1.11111e+60 spmb=1.11111e+15 spomb=0 spomb1=1.11111e+60
B4_CH4m (B4_h4m 0) capacitor c=2.5e-14
B4_RH4m (B4_h4m B4_fm) resistor r=1T
B4_SN5m (B4_h5m B4_ck5 B4_fm 0) nmos_lvt l=30n w=2u multi=1 nf=1 sd=100n ad=1.5e-13 as=1.5e-13 pd=4.15u ps=4.15u nrd=0.144730 nrs=0.144730 sa=75.0n sb=75.0n sa1=75.0n sa2=75.0n sa3=75.0n sa4=75.0n sb1=75.0n sb2=75.0n sb3=75.0n spa=100n spa1=100n spa2=100n spa3=100n sap=91.9776n sapb=114.444n spba=115.715n spba1=117.043n dfm_flag=0 _ccoflag=1 _rcoflag=1 _rgflag=1 spmt=1.11111e+15 spomt=0 spomt1=1.11111e+60 spmb=1.11111e+15 spomb=0 spomb1=1.11111e+60
B4_SP5m (B4_h5m B4_kb5 B4_fm bankvdd) pmos_lvt l=30n w=2u multi=1 nf=1 sd=100n ad=1.5e-13 as=1.5e-13 pd=4.15u ps=4.15u nrd=0.082877 nrs=0.082877 sa=75.0n sb=75.0n sa1=75.0n sa2=75.0n sa3=75.0n sa4=75.0n sb1=75.0n sb2=75.0n sb3=75.0n spa=100n spa1=100n spa2=100n spa3=100n sap=91.9776n sapb=114.444n spba=115.715n spba1=117.043n dfm_flag=0 _ccoflag=1 _rcoflag=1 _rgflag=1 spmt=1.11111e+15 spomt=0 spomt1=1.11111e+60 spmb=1.11111e+15 spomb=0 spomb1=1.11111e+60
B4_CH5m (B4_h5m 0) capacitor c=2.5e-14
B4_RH5m (B4_h5m B4_fm) resistor r=1T
B4_SN6m (B4_h6m B4_ck6 B4_fm 0) nmos_lvt l=30n w=2u multi=1 nf=1 sd=100n ad=1.5e-13 as=1.5e-13 pd=4.15u ps=4.15u nrd=0.144730 nrs=0.144730 sa=75.0n sb=75.0n sa1=75.0n sa2=75.0n sa3=75.0n sa4=75.0n sb1=75.0n sb2=75.0n sb3=75.0n spa=100n spa1=100n spa2=100n spa3=100n sap=91.9776n sapb=114.444n spba=115.715n spba1=117.043n dfm_flag=0 _ccoflag=1 _rcoflag=1 _rgflag=1 spmt=1.11111e+15 spomt=0 spomt1=1.11111e+60 spmb=1.11111e+15 spomb=0 spomb1=1.11111e+60
B4_SP6m (B4_h6m B4_kb6 B4_fm bankvdd) pmos_lvt l=30n w=2u multi=1 nf=1 sd=100n ad=1.5e-13 as=1.5e-13 pd=4.15u ps=4.15u nrd=0.082877 nrs=0.082877 sa=75.0n sb=75.0n sa1=75.0n sa2=75.0n sa3=75.0n sa4=75.0n sb1=75.0n sb2=75.0n sb3=75.0n spa=100n spa1=100n spa2=100n spa3=100n sap=91.9776n sapb=114.444n spba=115.715n spba1=117.043n dfm_flag=0 _ccoflag=1 _rcoflag=1 _rgflag=1 spmt=1.11111e+15 spomt=0 spomt1=1.11111e+60 spmb=1.11111e+15 spomb=0 spomb1=1.11111e+60
B4_CH6m (B4_h6m 0) capacitor c=2.5e-14
B4_RH6m (B4_h6m B4_fm) resistor r=1T
B4_SN7m (B4_h7m B4_ck7 B4_fm 0) nmos_lvt l=30n w=2u multi=1 nf=1 sd=100n ad=1.5e-13 as=1.5e-13 pd=4.15u ps=4.15u nrd=0.144730 nrs=0.144730 sa=75.0n sb=75.0n sa1=75.0n sa2=75.0n sa3=75.0n sa4=75.0n sb1=75.0n sb2=75.0n sb3=75.0n spa=100n spa1=100n spa2=100n spa3=100n sap=91.9776n sapb=114.444n spba=115.715n spba1=117.043n dfm_flag=0 _ccoflag=1 _rcoflag=1 _rgflag=1 spmt=1.11111e+15 spomt=0 spomt1=1.11111e+60 spmb=1.11111e+15 spomb=0 spomb1=1.11111e+60
B4_SP7m (B4_h7m B4_kb7 B4_fm bankvdd) pmos_lvt l=30n w=2u multi=1 nf=1 sd=100n ad=1.5e-13 as=1.5e-13 pd=4.15u ps=4.15u nrd=0.082877 nrs=0.082877 sa=75.0n sb=75.0n sa1=75.0n sa2=75.0n sa3=75.0n sa4=75.0n sb1=75.0n sb2=75.0n sb3=75.0n spa=100n spa1=100n spa2=100n spa3=100n sap=91.9776n sapb=114.444n spba=115.715n spba1=117.043n dfm_flag=0 _ccoflag=1 _rcoflag=1 _rgflag=1 spmt=1.11111e+15 spomt=0 spomt1=1.11111e+60 spmb=1.11111e+15 spomb=0 spomb1=1.11111e+60
B4_CH7m (B4_h7m 0) capacitor c=2.5e-14
B4_RH7m (B4_h7m B4_fm) resistor r=1T
B4_RDEG (B4_ep B4_em) resistor r=250
B4_COMP0 (B4_h0p B4_h0m compvdd logicvdd) COMPLOAD
B4_COMP1 (B4_h1p B4_h1m compvdd logicvdd) COMPLOAD
B4_COMP2 (B4_h2p B4_h2m compvdd logicvdd) COMPLOAD
B4_COMP3 (B4_h3p B4_h3m compvdd logicvdd) COMPLOAD
B4_COMP4 (B4_h4p B4_h4m compvdd logicvdd) COMPLOAD
B4_COMP5 (B4_h5p B4_h5m compvdd logicvdd) COMPLOAD
B4_COMP6 (B4_h6p B4_h6m compvdd logicvdd) COMPLOAD
B4_COMP7 (B4_h7p B4_h7m compvdd logicvdd) COMPLOAD
B5_ck0V (B5_ck0 0) vsource type=pulse val0=0 val1=0.9 delay=1.488751428571429e-10 rise=1e-12 fall=1e-12 width=6.471429999999999e-11 period=5.714288e-10
B5_kb0V (B5_kb0 0) vsource type=pulse val0=0.9 val1=0 delay=1.488751428571429e-10 rise=1e-12 fall=1e-12 width=6.471429999999999e-11 period=5.714288e-10
B5_ck1V (B5_ck1 0) vsource type=pulse val0=0 val1=0.9 delay=2.203037428571429e-10 rise=1e-12 fall=1e-12 width=6.471429999999999e-11 period=5.714288e-10
B5_kb1V (B5_kb1 0) vsource type=pulse val0=0.9 val1=0 delay=2.203037428571429e-10 rise=1e-12 fall=1e-12 width=6.471429999999999e-11 period=5.714288e-10
B5_ck2V (B5_ck2 0) vsource type=pulse val0=0 val1=0.9 delay=2.917323428571429e-10 rise=1e-12 fall=1e-12 width=6.471429999999999e-11 period=5.714288e-10
B5_kb2V (B5_kb2 0) vsource type=pulse val0=0.9 val1=0 delay=2.917323428571429e-10 rise=1e-12 fall=1e-12 width=6.471429999999999e-11 period=5.714288e-10
B5_ck3V (B5_ck3 0) vsource type=pulse val0=0 val1=0.9 delay=3.631609428571429e-10 rise=1e-12 fall=1e-12 width=6.471429999999999e-11 period=5.714288e-10
B5_kb3V (B5_kb3 0) vsource type=pulse val0=0.9 val1=0 delay=3.631609428571429e-10 rise=1e-12 fall=1e-12 width=6.471429999999999e-11 period=5.714288e-10
B5_ck4V (B5_ck4 0) vsource type=pulse val0=0 val1=0.9 delay=4.345895428571429e-10 rise=1e-12 fall=1e-12 width=6.471429999999999e-11 period=5.714288e-10
B5_kb4V (B5_kb4 0) vsource type=pulse val0=0.9 val1=0 delay=4.345895428571429e-10 rise=1e-12 fall=1e-12 width=6.471429999999999e-11 period=5.714288e-10
B5_ck5V (B5_ck5 0) vsource type=pulse val0=0 val1=0.9 delay=5.060181428571428e-10 rise=1e-12 fall=1e-12 width=6.471429999999999e-11 period=5.714288e-10
B5_kb5V (B5_kb5 0) vsource type=pulse val0=0.9 val1=0 delay=5.060181428571428e-10 rise=1e-12 fall=1e-12 width=6.471429999999999e-11 period=5.714288e-10
B5_ck6V (B5_ck6 0) vsource type=pulse val0=0 val1=0.9 delay=5.774467428571428e-10 rise=1e-12 fall=1e-12 width=6.471429999999999e-11 period=5.714288e-10
B5_kb6V (B5_kb6 0) vsource type=pulse val0=0.9 val1=0 delay=5.774467428571428e-10 rise=1e-12 fall=1e-12 width=6.471429999999999e-11 period=5.714288e-10
B5_ck7V (B5_ck7 0) vsource type=pulse val0=0 val1=0.9 delay=6.488753428571428e-10 rise=1e-12 fall=1e-12 width=6.471429999999999e-11 period=5.714288e-10
B5_kb7V (B5_kb7 0) vsource type=pulse val0=0.9 val1=0 delay=6.488753428571428e-10 rise=1e-12 fall=1e-12 width=6.471429999999999e-11 period=5.714288e-10
RB5_Lp (bankvdd B5_fp) resistor r=500
B5_Fp (B5_fp X_h5p B5_ep 0) nmos_lvt l=30n w=2u multi=1 nf=1 sd=100n ad=1.5e-13 as=1.5e-13 pd=4.15u ps=4.15u nrd=0.144730 nrs=0.144730 sa=75.0n sb=75.0n sa1=75.0n sa2=75.0n sa3=75.0n sa4=75.0n sb1=75.0n sb2=75.0n sb3=75.0n spa=100n spa1=100n spa2=100n spa3=100n sap=91.9776n sapb=114.444n spba=115.715n spba1=117.043n dfm_flag=0 _ccoflag=1 _rcoflag=1 _rgflag=1 spmt=1.11111e+15 spomt=0 spomt1=1.11111e+60 spmb=1.11111e+15 spomb=0 spomb1=1.11111e+60
B5_Tp (B5_ep nbias 0 0) nmos_lvt l=60n w=2u multi=1 nf=1 sd=100n ad=1.5e-13 as=1.5e-13 pd=4.15u ps=4.15u nrd=0.144730 nrs=0.144730 sa=75.0n sb=75.0n sa1=75.0n sa2=75.0n sa3=75.0n sa4=75.0n sb1=75.0n sb2=75.0n sb3=75.0n spa=100n spa1=100n spa2=100n spa3=100n sap=91.9776n sapb=120.93n spba=121.82n spba1=124.403n dfm_flag=0 _ccoflag=1 _rcoflag=1 _rgflag=1 spmt=1.11111e+15 spomt=0 spomt1=1.11111e+60 spmb=1.11111e+15 spomb=0 spomb1=1.11111e+60
B5_SN0p (B5_h0p B5_ck0 B5_fp 0) nmos_lvt l=30n w=2u multi=1 nf=1 sd=100n ad=1.5e-13 as=1.5e-13 pd=4.15u ps=4.15u nrd=0.144730 nrs=0.144730 sa=75.0n sb=75.0n sa1=75.0n sa2=75.0n sa3=75.0n sa4=75.0n sb1=75.0n sb2=75.0n sb3=75.0n spa=100n spa1=100n spa2=100n spa3=100n sap=91.9776n sapb=114.444n spba=115.715n spba1=117.043n dfm_flag=0 _ccoflag=1 _rcoflag=1 _rgflag=1 spmt=1.11111e+15 spomt=0 spomt1=1.11111e+60 spmb=1.11111e+15 spomb=0 spomb1=1.11111e+60
B5_SP0p (B5_h0p B5_kb0 B5_fp bankvdd) pmos_lvt l=30n w=2u multi=1 nf=1 sd=100n ad=1.5e-13 as=1.5e-13 pd=4.15u ps=4.15u nrd=0.082877 nrs=0.082877 sa=75.0n sb=75.0n sa1=75.0n sa2=75.0n sa3=75.0n sa4=75.0n sb1=75.0n sb2=75.0n sb3=75.0n spa=100n spa1=100n spa2=100n spa3=100n sap=91.9776n sapb=114.444n spba=115.715n spba1=117.043n dfm_flag=0 _ccoflag=1 _rcoflag=1 _rgflag=1 spmt=1.11111e+15 spomt=0 spomt1=1.11111e+60 spmb=1.11111e+15 spomb=0 spomb1=1.11111e+60
B5_CH0p (B5_h0p 0) capacitor c=2.5e-14
B5_RH0p (B5_h0p B5_fp) resistor r=1T
B5_SN1p (B5_h1p B5_ck1 B5_fp 0) nmos_lvt l=30n w=2u multi=1 nf=1 sd=100n ad=1.5e-13 as=1.5e-13 pd=4.15u ps=4.15u nrd=0.144730 nrs=0.144730 sa=75.0n sb=75.0n sa1=75.0n sa2=75.0n sa3=75.0n sa4=75.0n sb1=75.0n sb2=75.0n sb3=75.0n spa=100n spa1=100n spa2=100n spa3=100n sap=91.9776n sapb=114.444n spba=115.715n spba1=117.043n dfm_flag=0 _ccoflag=1 _rcoflag=1 _rgflag=1 spmt=1.11111e+15 spomt=0 spomt1=1.11111e+60 spmb=1.11111e+15 spomb=0 spomb1=1.11111e+60
B5_SP1p (B5_h1p B5_kb1 B5_fp bankvdd) pmos_lvt l=30n w=2u multi=1 nf=1 sd=100n ad=1.5e-13 as=1.5e-13 pd=4.15u ps=4.15u nrd=0.082877 nrs=0.082877 sa=75.0n sb=75.0n sa1=75.0n sa2=75.0n sa3=75.0n sa4=75.0n sb1=75.0n sb2=75.0n sb3=75.0n spa=100n spa1=100n spa2=100n spa3=100n sap=91.9776n sapb=114.444n spba=115.715n spba1=117.043n dfm_flag=0 _ccoflag=1 _rcoflag=1 _rgflag=1 spmt=1.11111e+15 spomt=0 spomt1=1.11111e+60 spmb=1.11111e+15 spomb=0 spomb1=1.11111e+60
B5_CH1p (B5_h1p 0) capacitor c=2.5e-14
B5_RH1p (B5_h1p B5_fp) resistor r=1T
B5_SN2p (B5_h2p B5_ck2 B5_fp 0) nmos_lvt l=30n w=2u multi=1 nf=1 sd=100n ad=1.5e-13 as=1.5e-13 pd=4.15u ps=4.15u nrd=0.144730 nrs=0.144730 sa=75.0n sb=75.0n sa1=75.0n sa2=75.0n sa3=75.0n sa4=75.0n sb1=75.0n sb2=75.0n sb3=75.0n spa=100n spa1=100n spa2=100n spa3=100n sap=91.9776n sapb=114.444n spba=115.715n spba1=117.043n dfm_flag=0 _ccoflag=1 _rcoflag=1 _rgflag=1 spmt=1.11111e+15 spomt=0 spomt1=1.11111e+60 spmb=1.11111e+15 spomb=0 spomb1=1.11111e+60
B5_SP2p (B5_h2p B5_kb2 B5_fp bankvdd) pmos_lvt l=30n w=2u multi=1 nf=1 sd=100n ad=1.5e-13 as=1.5e-13 pd=4.15u ps=4.15u nrd=0.082877 nrs=0.082877 sa=75.0n sb=75.0n sa1=75.0n sa2=75.0n sa3=75.0n sa4=75.0n sb1=75.0n sb2=75.0n sb3=75.0n spa=100n spa1=100n spa2=100n spa3=100n sap=91.9776n sapb=114.444n spba=115.715n spba1=117.043n dfm_flag=0 _ccoflag=1 _rcoflag=1 _rgflag=1 spmt=1.11111e+15 spomt=0 spomt1=1.11111e+60 spmb=1.11111e+15 spomb=0 spomb1=1.11111e+60
B5_CH2p (B5_h2p 0) capacitor c=2.5e-14
B5_RH2p (B5_h2p B5_fp) resistor r=1T
B5_SN3p (B5_h3p B5_ck3 B5_fp 0) nmos_lvt l=30n w=2u multi=1 nf=1 sd=100n ad=1.5e-13 as=1.5e-13 pd=4.15u ps=4.15u nrd=0.144730 nrs=0.144730 sa=75.0n sb=75.0n sa1=75.0n sa2=75.0n sa3=75.0n sa4=75.0n sb1=75.0n sb2=75.0n sb3=75.0n spa=100n spa1=100n spa2=100n spa3=100n sap=91.9776n sapb=114.444n spba=115.715n spba1=117.043n dfm_flag=0 _ccoflag=1 _rcoflag=1 _rgflag=1 spmt=1.11111e+15 spomt=0 spomt1=1.11111e+60 spmb=1.11111e+15 spomb=0 spomb1=1.11111e+60
B5_SP3p (B5_h3p B5_kb3 B5_fp bankvdd) pmos_lvt l=30n w=2u multi=1 nf=1 sd=100n ad=1.5e-13 as=1.5e-13 pd=4.15u ps=4.15u nrd=0.082877 nrs=0.082877 sa=75.0n sb=75.0n sa1=75.0n sa2=75.0n sa3=75.0n sa4=75.0n sb1=75.0n sb2=75.0n sb3=75.0n spa=100n spa1=100n spa2=100n spa3=100n sap=91.9776n sapb=114.444n spba=115.715n spba1=117.043n dfm_flag=0 _ccoflag=1 _rcoflag=1 _rgflag=1 spmt=1.11111e+15 spomt=0 spomt1=1.11111e+60 spmb=1.11111e+15 spomb=0 spomb1=1.11111e+60
B5_CH3p (B5_h3p 0) capacitor c=2.5e-14
B5_RH3p (B5_h3p B5_fp) resistor r=1T
B5_SN4p (B5_h4p B5_ck4 B5_fp 0) nmos_lvt l=30n w=2u multi=1 nf=1 sd=100n ad=1.5e-13 as=1.5e-13 pd=4.15u ps=4.15u nrd=0.144730 nrs=0.144730 sa=75.0n sb=75.0n sa1=75.0n sa2=75.0n sa3=75.0n sa4=75.0n sb1=75.0n sb2=75.0n sb3=75.0n spa=100n spa1=100n spa2=100n spa3=100n sap=91.9776n sapb=114.444n spba=115.715n spba1=117.043n dfm_flag=0 _ccoflag=1 _rcoflag=1 _rgflag=1 spmt=1.11111e+15 spomt=0 spomt1=1.11111e+60 spmb=1.11111e+15 spomb=0 spomb1=1.11111e+60
B5_SP4p (B5_h4p B5_kb4 B5_fp bankvdd) pmos_lvt l=30n w=2u multi=1 nf=1 sd=100n ad=1.5e-13 as=1.5e-13 pd=4.15u ps=4.15u nrd=0.082877 nrs=0.082877 sa=75.0n sb=75.0n sa1=75.0n sa2=75.0n sa3=75.0n sa4=75.0n sb1=75.0n sb2=75.0n sb3=75.0n spa=100n spa1=100n spa2=100n spa3=100n sap=91.9776n sapb=114.444n spba=115.715n spba1=117.043n dfm_flag=0 _ccoflag=1 _rcoflag=1 _rgflag=1 spmt=1.11111e+15 spomt=0 spomt1=1.11111e+60 spmb=1.11111e+15 spomb=0 spomb1=1.11111e+60
B5_CH4p (B5_h4p 0) capacitor c=2.5e-14
B5_RH4p (B5_h4p B5_fp) resistor r=1T
B5_SN5p (B5_h5p B5_ck5 B5_fp 0) nmos_lvt l=30n w=2u multi=1 nf=1 sd=100n ad=1.5e-13 as=1.5e-13 pd=4.15u ps=4.15u nrd=0.144730 nrs=0.144730 sa=75.0n sb=75.0n sa1=75.0n sa2=75.0n sa3=75.0n sa4=75.0n sb1=75.0n sb2=75.0n sb3=75.0n spa=100n spa1=100n spa2=100n spa3=100n sap=91.9776n sapb=114.444n spba=115.715n spba1=117.043n dfm_flag=0 _ccoflag=1 _rcoflag=1 _rgflag=1 spmt=1.11111e+15 spomt=0 spomt1=1.11111e+60 spmb=1.11111e+15 spomb=0 spomb1=1.11111e+60
B5_SP5p (B5_h5p B5_kb5 B5_fp bankvdd) pmos_lvt l=30n w=2u multi=1 nf=1 sd=100n ad=1.5e-13 as=1.5e-13 pd=4.15u ps=4.15u nrd=0.082877 nrs=0.082877 sa=75.0n sb=75.0n sa1=75.0n sa2=75.0n sa3=75.0n sa4=75.0n sb1=75.0n sb2=75.0n sb3=75.0n spa=100n spa1=100n spa2=100n spa3=100n sap=91.9776n sapb=114.444n spba=115.715n spba1=117.043n dfm_flag=0 _ccoflag=1 _rcoflag=1 _rgflag=1 spmt=1.11111e+15 spomt=0 spomt1=1.11111e+60 spmb=1.11111e+15 spomb=0 spomb1=1.11111e+60
B5_CH5p (B5_h5p 0) capacitor c=2.5e-14
B5_RH5p (B5_h5p B5_fp) resistor r=1T
B5_SN6p (B5_h6p B5_ck6 B5_fp 0) nmos_lvt l=30n w=2u multi=1 nf=1 sd=100n ad=1.5e-13 as=1.5e-13 pd=4.15u ps=4.15u nrd=0.144730 nrs=0.144730 sa=75.0n sb=75.0n sa1=75.0n sa2=75.0n sa3=75.0n sa4=75.0n sb1=75.0n sb2=75.0n sb3=75.0n spa=100n spa1=100n spa2=100n spa3=100n sap=91.9776n sapb=114.444n spba=115.715n spba1=117.043n dfm_flag=0 _ccoflag=1 _rcoflag=1 _rgflag=1 spmt=1.11111e+15 spomt=0 spomt1=1.11111e+60 spmb=1.11111e+15 spomb=0 spomb1=1.11111e+60
B5_SP6p (B5_h6p B5_kb6 B5_fp bankvdd) pmos_lvt l=30n w=2u multi=1 nf=1 sd=100n ad=1.5e-13 as=1.5e-13 pd=4.15u ps=4.15u nrd=0.082877 nrs=0.082877 sa=75.0n sb=75.0n sa1=75.0n sa2=75.0n sa3=75.0n sa4=75.0n sb1=75.0n sb2=75.0n sb3=75.0n spa=100n spa1=100n spa2=100n spa3=100n sap=91.9776n sapb=114.444n spba=115.715n spba1=117.043n dfm_flag=0 _ccoflag=1 _rcoflag=1 _rgflag=1 spmt=1.11111e+15 spomt=0 spomt1=1.11111e+60 spmb=1.11111e+15 spomb=0 spomb1=1.11111e+60
B5_CH6p (B5_h6p 0) capacitor c=2.5e-14
B5_RH6p (B5_h6p B5_fp) resistor r=1T
B5_SN7p (B5_h7p B5_ck7 B5_fp 0) nmos_lvt l=30n w=2u multi=1 nf=1 sd=100n ad=1.5e-13 as=1.5e-13 pd=4.15u ps=4.15u nrd=0.144730 nrs=0.144730 sa=75.0n sb=75.0n sa1=75.0n sa2=75.0n sa3=75.0n sa4=75.0n sb1=75.0n sb2=75.0n sb3=75.0n spa=100n spa1=100n spa2=100n spa3=100n sap=91.9776n sapb=114.444n spba=115.715n spba1=117.043n dfm_flag=0 _ccoflag=1 _rcoflag=1 _rgflag=1 spmt=1.11111e+15 spomt=0 spomt1=1.11111e+60 spmb=1.11111e+15 spomb=0 spomb1=1.11111e+60
B5_SP7p (B5_h7p B5_kb7 B5_fp bankvdd) pmos_lvt l=30n w=2u multi=1 nf=1 sd=100n ad=1.5e-13 as=1.5e-13 pd=4.15u ps=4.15u nrd=0.082877 nrs=0.082877 sa=75.0n sb=75.0n sa1=75.0n sa2=75.0n sa3=75.0n sa4=75.0n sb1=75.0n sb2=75.0n sb3=75.0n spa=100n spa1=100n spa2=100n spa3=100n sap=91.9776n sapb=114.444n spba=115.715n spba1=117.043n dfm_flag=0 _ccoflag=1 _rcoflag=1 _rgflag=1 spmt=1.11111e+15 spomt=0 spomt1=1.11111e+60 spmb=1.11111e+15 spomb=0 spomb1=1.11111e+60
B5_CH7p (B5_h7p 0) capacitor c=2.5e-14
B5_RH7p (B5_h7p B5_fp) resistor r=1T
RB5_Lm (bankvdd B5_fm) resistor r=500
B5_Fm (B5_fm X_h5m B5_em 0) nmos_lvt l=30n w=2u multi=1 nf=1 sd=100n ad=1.5e-13 as=1.5e-13 pd=4.15u ps=4.15u nrd=0.144730 nrs=0.144730 sa=75.0n sb=75.0n sa1=75.0n sa2=75.0n sa3=75.0n sa4=75.0n sb1=75.0n sb2=75.0n sb3=75.0n spa=100n spa1=100n spa2=100n spa3=100n sap=91.9776n sapb=114.444n spba=115.715n spba1=117.043n dfm_flag=0 _ccoflag=1 _rcoflag=1 _rgflag=1 spmt=1.11111e+15 spomt=0 spomt1=1.11111e+60 spmb=1.11111e+15 spomb=0 spomb1=1.11111e+60
B5_Tm (B5_em nbias 0 0) nmos_lvt l=60n w=2u multi=1 nf=1 sd=100n ad=1.5e-13 as=1.5e-13 pd=4.15u ps=4.15u nrd=0.144730 nrs=0.144730 sa=75.0n sb=75.0n sa1=75.0n sa2=75.0n sa3=75.0n sa4=75.0n sb1=75.0n sb2=75.0n sb3=75.0n spa=100n spa1=100n spa2=100n spa3=100n sap=91.9776n sapb=120.93n spba=121.82n spba1=124.403n dfm_flag=0 _ccoflag=1 _rcoflag=1 _rgflag=1 spmt=1.11111e+15 spomt=0 spomt1=1.11111e+60 spmb=1.11111e+15 spomb=0 spomb1=1.11111e+60
B5_SN0m (B5_h0m B5_ck0 B5_fm 0) nmos_lvt l=30n w=2u multi=1 nf=1 sd=100n ad=1.5e-13 as=1.5e-13 pd=4.15u ps=4.15u nrd=0.144730 nrs=0.144730 sa=75.0n sb=75.0n sa1=75.0n sa2=75.0n sa3=75.0n sa4=75.0n sb1=75.0n sb2=75.0n sb3=75.0n spa=100n spa1=100n spa2=100n spa3=100n sap=91.9776n sapb=114.444n spba=115.715n spba1=117.043n dfm_flag=0 _ccoflag=1 _rcoflag=1 _rgflag=1 spmt=1.11111e+15 spomt=0 spomt1=1.11111e+60 spmb=1.11111e+15 spomb=0 spomb1=1.11111e+60
B5_SP0m (B5_h0m B5_kb0 B5_fm bankvdd) pmos_lvt l=30n w=2u multi=1 nf=1 sd=100n ad=1.5e-13 as=1.5e-13 pd=4.15u ps=4.15u nrd=0.082877 nrs=0.082877 sa=75.0n sb=75.0n sa1=75.0n sa2=75.0n sa3=75.0n sa4=75.0n sb1=75.0n sb2=75.0n sb3=75.0n spa=100n spa1=100n spa2=100n spa3=100n sap=91.9776n sapb=114.444n spba=115.715n spba1=117.043n dfm_flag=0 _ccoflag=1 _rcoflag=1 _rgflag=1 spmt=1.11111e+15 spomt=0 spomt1=1.11111e+60 spmb=1.11111e+15 spomb=0 spomb1=1.11111e+60
B5_CH0m (B5_h0m 0) capacitor c=2.5e-14
B5_RH0m (B5_h0m B5_fm) resistor r=1T
B5_SN1m (B5_h1m B5_ck1 B5_fm 0) nmos_lvt l=30n w=2u multi=1 nf=1 sd=100n ad=1.5e-13 as=1.5e-13 pd=4.15u ps=4.15u nrd=0.144730 nrs=0.144730 sa=75.0n sb=75.0n sa1=75.0n sa2=75.0n sa3=75.0n sa4=75.0n sb1=75.0n sb2=75.0n sb3=75.0n spa=100n spa1=100n spa2=100n spa3=100n sap=91.9776n sapb=114.444n spba=115.715n spba1=117.043n dfm_flag=0 _ccoflag=1 _rcoflag=1 _rgflag=1 spmt=1.11111e+15 spomt=0 spomt1=1.11111e+60 spmb=1.11111e+15 spomb=0 spomb1=1.11111e+60
B5_SP1m (B5_h1m B5_kb1 B5_fm bankvdd) pmos_lvt l=30n w=2u multi=1 nf=1 sd=100n ad=1.5e-13 as=1.5e-13 pd=4.15u ps=4.15u nrd=0.082877 nrs=0.082877 sa=75.0n sb=75.0n sa1=75.0n sa2=75.0n sa3=75.0n sa4=75.0n sb1=75.0n sb2=75.0n sb3=75.0n spa=100n spa1=100n spa2=100n spa3=100n sap=91.9776n sapb=114.444n spba=115.715n spba1=117.043n dfm_flag=0 _ccoflag=1 _rcoflag=1 _rgflag=1 spmt=1.11111e+15 spomt=0 spomt1=1.11111e+60 spmb=1.11111e+15 spomb=0 spomb1=1.11111e+60
B5_CH1m (B5_h1m 0) capacitor c=2.5e-14
B5_RH1m (B5_h1m B5_fm) resistor r=1T
B5_SN2m (B5_h2m B5_ck2 B5_fm 0) nmos_lvt l=30n w=2u multi=1 nf=1 sd=100n ad=1.5e-13 as=1.5e-13 pd=4.15u ps=4.15u nrd=0.144730 nrs=0.144730 sa=75.0n sb=75.0n sa1=75.0n sa2=75.0n sa3=75.0n sa4=75.0n sb1=75.0n sb2=75.0n sb3=75.0n spa=100n spa1=100n spa2=100n spa3=100n sap=91.9776n sapb=114.444n spba=115.715n spba1=117.043n dfm_flag=0 _ccoflag=1 _rcoflag=1 _rgflag=1 spmt=1.11111e+15 spomt=0 spomt1=1.11111e+60 spmb=1.11111e+15 spomb=0 spomb1=1.11111e+60
B5_SP2m (B5_h2m B5_kb2 B5_fm bankvdd) pmos_lvt l=30n w=2u multi=1 nf=1 sd=100n ad=1.5e-13 as=1.5e-13 pd=4.15u ps=4.15u nrd=0.082877 nrs=0.082877 sa=75.0n sb=75.0n sa1=75.0n sa2=75.0n sa3=75.0n sa4=75.0n sb1=75.0n sb2=75.0n sb3=75.0n spa=100n spa1=100n spa2=100n spa3=100n sap=91.9776n sapb=114.444n spba=115.715n spba1=117.043n dfm_flag=0 _ccoflag=1 _rcoflag=1 _rgflag=1 spmt=1.11111e+15 spomt=0 spomt1=1.11111e+60 spmb=1.11111e+15 spomb=0 spomb1=1.11111e+60
B5_CH2m (B5_h2m 0) capacitor c=2.5e-14
B5_RH2m (B5_h2m B5_fm) resistor r=1T
B5_SN3m (B5_h3m B5_ck3 B5_fm 0) nmos_lvt l=30n w=2u multi=1 nf=1 sd=100n ad=1.5e-13 as=1.5e-13 pd=4.15u ps=4.15u nrd=0.144730 nrs=0.144730 sa=75.0n sb=75.0n sa1=75.0n sa2=75.0n sa3=75.0n sa4=75.0n sb1=75.0n sb2=75.0n sb3=75.0n spa=100n spa1=100n spa2=100n spa3=100n sap=91.9776n sapb=114.444n spba=115.715n spba1=117.043n dfm_flag=0 _ccoflag=1 _rcoflag=1 _rgflag=1 spmt=1.11111e+15 spomt=0 spomt1=1.11111e+60 spmb=1.11111e+15 spomb=0 spomb1=1.11111e+60
B5_SP3m (B5_h3m B5_kb3 B5_fm bankvdd) pmos_lvt l=30n w=2u multi=1 nf=1 sd=100n ad=1.5e-13 as=1.5e-13 pd=4.15u ps=4.15u nrd=0.082877 nrs=0.082877 sa=75.0n sb=75.0n sa1=75.0n sa2=75.0n sa3=75.0n sa4=75.0n sb1=75.0n sb2=75.0n sb3=75.0n spa=100n spa1=100n spa2=100n spa3=100n sap=91.9776n sapb=114.444n spba=115.715n spba1=117.043n dfm_flag=0 _ccoflag=1 _rcoflag=1 _rgflag=1 spmt=1.11111e+15 spomt=0 spomt1=1.11111e+60 spmb=1.11111e+15 spomb=0 spomb1=1.11111e+60
B5_CH3m (B5_h3m 0) capacitor c=2.5e-14
B5_RH3m (B5_h3m B5_fm) resistor r=1T
B5_SN4m (B5_h4m B5_ck4 B5_fm 0) nmos_lvt l=30n w=2u multi=1 nf=1 sd=100n ad=1.5e-13 as=1.5e-13 pd=4.15u ps=4.15u nrd=0.144730 nrs=0.144730 sa=75.0n sb=75.0n sa1=75.0n sa2=75.0n sa3=75.0n sa4=75.0n sb1=75.0n sb2=75.0n sb3=75.0n spa=100n spa1=100n spa2=100n spa3=100n sap=91.9776n sapb=114.444n spba=115.715n spba1=117.043n dfm_flag=0 _ccoflag=1 _rcoflag=1 _rgflag=1 spmt=1.11111e+15 spomt=0 spomt1=1.11111e+60 spmb=1.11111e+15 spomb=0 spomb1=1.11111e+60
B5_SP4m (B5_h4m B5_kb4 B5_fm bankvdd) pmos_lvt l=30n w=2u multi=1 nf=1 sd=100n ad=1.5e-13 as=1.5e-13 pd=4.15u ps=4.15u nrd=0.082877 nrs=0.082877 sa=75.0n sb=75.0n sa1=75.0n sa2=75.0n sa3=75.0n sa4=75.0n sb1=75.0n sb2=75.0n sb3=75.0n spa=100n spa1=100n spa2=100n spa3=100n sap=91.9776n sapb=114.444n spba=115.715n spba1=117.043n dfm_flag=0 _ccoflag=1 _rcoflag=1 _rgflag=1 spmt=1.11111e+15 spomt=0 spomt1=1.11111e+60 spmb=1.11111e+15 spomb=0 spomb1=1.11111e+60
B5_CH4m (B5_h4m 0) capacitor c=2.5e-14
B5_RH4m (B5_h4m B5_fm) resistor r=1T
B5_SN5m (B5_h5m B5_ck5 B5_fm 0) nmos_lvt l=30n w=2u multi=1 nf=1 sd=100n ad=1.5e-13 as=1.5e-13 pd=4.15u ps=4.15u nrd=0.144730 nrs=0.144730 sa=75.0n sb=75.0n sa1=75.0n sa2=75.0n sa3=75.0n sa4=75.0n sb1=75.0n sb2=75.0n sb3=75.0n spa=100n spa1=100n spa2=100n spa3=100n sap=91.9776n sapb=114.444n spba=115.715n spba1=117.043n dfm_flag=0 _ccoflag=1 _rcoflag=1 _rgflag=1 spmt=1.11111e+15 spomt=0 spomt1=1.11111e+60 spmb=1.11111e+15 spomb=0 spomb1=1.11111e+60
B5_SP5m (B5_h5m B5_kb5 B5_fm bankvdd) pmos_lvt l=30n w=2u multi=1 nf=1 sd=100n ad=1.5e-13 as=1.5e-13 pd=4.15u ps=4.15u nrd=0.082877 nrs=0.082877 sa=75.0n sb=75.0n sa1=75.0n sa2=75.0n sa3=75.0n sa4=75.0n sb1=75.0n sb2=75.0n sb3=75.0n spa=100n spa1=100n spa2=100n spa3=100n sap=91.9776n sapb=114.444n spba=115.715n spba1=117.043n dfm_flag=0 _ccoflag=1 _rcoflag=1 _rgflag=1 spmt=1.11111e+15 spomt=0 spomt1=1.11111e+60 spmb=1.11111e+15 spomb=0 spomb1=1.11111e+60
B5_CH5m (B5_h5m 0) capacitor c=2.5e-14
B5_RH5m (B5_h5m B5_fm) resistor r=1T
B5_SN6m (B5_h6m B5_ck6 B5_fm 0) nmos_lvt l=30n w=2u multi=1 nf=1 sd=100n ad=1.5e-13 as=1.5e-13 pd=4.15u ps=4.15u nrd=0.144730 nrs=0.144730 sa=75.0n sb=75.0n sa1=75.0n sa2=75.0n sa3=75.0n sa4=75.0n sb1=75.0n sb2=75.0n sb3=75.0n spa=100n spa1=100n spa2=100n spa3=100n sap=91.9776n sapb=114.444n spba=115.715n spba1=117.043n dfm_flag=0 _ccoflag=1 _rcoflag=1 _rgflag=1 spmt=1.11111e+15 spomt=0 spomt1=1.11111e+60 spmb=1.11111e+15 spomb=0 spomb1=1.11111e+60
B5_SP6m (B5_h6m B5_kb6 B5_fm bankvdd) pmos_lvt l=30n w=2u multi=1 nf=1 sd=100n ad=1.5e-13 as=1.5e-13 pd=4.15u ps=4.15u nrd=0.082877 nrs=0.082877 sa=75.0n sb=75.0n sa1=75.0n sa2=75.0n sa3=75.0n sa4=75.0n sb1=75.0n sb2=75.0n sb3=75.0n spa=100n spa1=100n spa2=100n spa3=100n sap=91.9776n sapb=114.444n spba=115.715n spba1=117.043n dfm_flag=0 _ccoflag=1 _rcoflag=1 _rgflag=1 spmt=1.11111e+15 spomt=0 spomt1=1.11111e+60 spmb=1.11111e+15 spomb=0 spomb1=1.11111e+60
B5_CH6m (B5_h6m 0) capacitor c=2.5e-14
B5_RH6m (B5_h6m B5_fm) resistor r=1T
B5_SN7m (B5_h7m B5_ck7 B5_fm 0) nmos_lvt l=30n w=2u multi=1 nf=1 sd=100n ad=1.5e-13 as=1.5e-13 pd=4.15u ps=4.15u nrd=0.144730 nrs=0.144730 sa=75.0n sb=75.0n sa1=75.0n sa2=75.0n sa3=75.0n sa4=75.0n sb1=75.0n sb2=75.0n sb3=75.0n spa=100n spa1=100n spa2=100n spa3=100n sap=91.9776n sapb=114.444n spba=115.715n spba1=117.043n dfm_flag=0 _ccoflag=1 _rcoflag=1 _rgflag=1 spmt=1.11111e+15 spomt=0 spomt1=1.11111e+60 spmb=1.11111e+15 spomb=0 spomb1=1.11111e+60
B5_SP7m (B5_h7m B5_kb7 B5_fm bankvdd) pmos_lvt l=30n w=2u multi=1 nf=1 sd=100n ad=1.5e-13 as=1.5e-13 pd=4.15u ps=4.15u nrd=0.082877 nrs=0.082877 sa=75.0n sb=75.0n sa1=75.0n sa2=75.0n sa3=75.0n sa4=75.0n sb1=75.0n sb2=75.0n sb3=75.0n spa=100n spa1=100n spa2=100n spa3=100n sap=91.9776n sapb=114.444n spba=115.715n spba1=117.043n dfm_flag=0 _ccoflag=1 _rcoflag=1 _rgflag=1 spmt=1.11111e+15 spomt=0 spomt1=1.11111e+60 spmb=1.11111e+15 spomb=0 spomb1=1.11111e+60
B5_CH7m (B5_h7m 0) capacitor c=2.5e-14
B5_RH7m (B5_h7m B5_fm) resistor r=1T
B5_RDEG (B5_ep B5_em) resistor r=250
B5_COMP0 (B5_h0p B5_h0m compvdd logicvdd) COMPLOAD
B5_COMP1 (B5_h1p B5_h1m compvdd logicvdd) COMPLOAD
B5_COMP2 (B5_h2p B5_h2m compvdd logicvdd) COMPLOAD
B5_COMP3 (B5_h3p B5_h3m compvdd logicvdd) COMPLOAD
B5_COMP4 (B5_h4p B5_h4m compvdd logicvdd) COMPLOAD
B5_COMP5 (B5_h5p B5_h5m compvdd logicvdd) COMPLOAD
B5_COMP6 (B5_h6p B5_h6m compvdd logicvdd) COMPLOAD
B5_COMP7 (B5_h7p B5_h7m compvdd logicvdd) COMPLOAD
B6_ck0V (B6_ck0 0) vsource type=pulse val0=0 val1=0.9 delay=1.578031428571429e-10 rise=1e-12 fall=1e-12 width=6.471429999999999e-11 period=5.714288e-10
B6_kb0V (B6_kb0 0) vsource type=pulse val0=0.9 val1=0 delay=1.578031428571429e-10 rise=1e-12 fall=1e-12 width=6.471429999999999e-11 period=5.714288e-10
B6_ck1V (B6_ck1 0) vsource type=pulse val0=0 val1=0.9 delay=2.292317428571429e-10 rise=1e-12 fall=1e-12 width=6.471429999999999e-11 period=5.714288e-10
B6_kb1V (B6_kb1 0) vsource type=pulse val0=0.9 val1=0 delay=2.292317428571429e-10 rise=1e-12 fall=1e-12 width=6.471429999999999e-11 period=5.714288e-10
B6_ck2V (B6_ck2 0) vsource type=pulse val0=0 val1=0.9 delay=3.006603428571429e-10 rise=1e-12 fall=1e-12 width=6.471429999999999e-11 period=5.714288e-10
B6_kb2V (B6_kb2 0) vsource type=pulse val0=0.9 val1=0 delay=3.006603428571429e-10 rise=1e-12 fall=1e-12 width=6.471429999999999e-11 period=5.714288e-10
B6_ck3V (B6_ck3 0) vsource type=pulse val0=0 val1=0.9 delay=3.720889428571429e-10 rise=1e-12 fall=1e-12 width=6.471429999999999e-11 period=5.714288e-10
B6_kb3V (B6_kb3 0) vsource type=pulse val0=0.9 val1=0 delay=3.720889428571429e-10 rise=1e-12 fall=1e-12 width=6.471429999999999e-11 period=5.714288e-10
B6_ck4V (B6_ck4 0) vsource type=pulse val0=0 val1=0.9 delay=4.435175428571429e-10 rise=1e-12 fall=1e-12 width=6.471429999999999e-11 period=5.714288e-10
B6_kb4V (B6_kb4 0) vsource type=pulse val0=0.9 val1=0 delay=4.435175428571429e-10 rise=1e-12 fall=1e-12 width=6.471429999999999e-11 period=5.714288e-10
B6_ck5V (B6_ck5 0) vsource type=pulse val0=0 val1=0.9 delay=5.149461428571429e-10 rise=1e-12 fall=1e-12 width=6.471429999999999e-11 period=5.714288e-10
B6_kb5V (B6_kb5 0) vsource type=pulse val0=0.9 val1=0 delay=5.149461428571429e-10 rise=1e-12 fall=1e-12 width=6.471429999999999e-11 period=5.714288e-10
B6_ck6V (B6_ck6 0) vsource type=pulse val0=0 val1=0.9 delay=5.863747428571429e-10 rise=1e-12 fall=1e-12 width=6.471429999999999e-11 period=5.714288e-10
B6_kb6V (B6_kb6 0) vsource type=pulse val0=0.9 val1=0 delay=5.863747428571429e-10 rise=1e-12 fall=1e-12 width=6.471429999999999e-11 period=5.714288e-10
B6_ck7V (B6_ck7 0) vsource type=pulse val0=0 val1=0.9 delay=6.578033428571429e-10 rise=1e-12 fall=1e-12 width=6.471429999999999e-11 period=5.714288e-10
B6_kb7V (B6_kb7 0) vsource type=pulse val0=0.9 val1=0 delay=6.578033428571429e-10 rise=1e-12 fall=1e-12 width=6.471429999999999e-11 period=5.714288e-10
RB6_Lp (bankvdd B6_fp) resistor r=500
B6_Fp (B6_fp X_h6p B6_ep 0) nmos_lvt l=30n w=2u multi=1 nf=1 sd=100n ad=1.5e-13 as=1.5e-13 pd=4.15u ps=4.15u nrd=0.144730 nrs=0.144730 sa=75.0n sb=75.0n sa1=75.0n sa2=75.0n sa3=75.0n sa4=75.0n sb1=75.0n sb2=75.0n sb3=75.0n spa=100n spa1=100n spa2=100n spa3=100n sap=91.9776n sapb=114.444n spba=115.715n spba1=117.043n dfm_flag=0 _ccoflag=1 _rcoflag=1 _rgflag=1 spmt=1.11111e+15 spomt=0 spomt1=1.11111e+60 spmb=1.11111e+15 spomb=0 spomb1=1.11111e+60
B6_Tp (B6_ep nbias 0 0) nmos_lvt l=60n w=2u multi=1 nf=1 sd=100n ad=1.5e-13 as=1.5e-13 pd=4.15u ps=4.15u nrd=0.144730 nrs=0.144730 sa=75.0n sb=75.0n sa1=75.0n sa2=75.0n sa3=75.0n sa4=75.0n sb1=75.0n sb2=75.0n sb3=75.0n spa=100n spa1=100n spa2=100n spa3=100n sap=91.9776n sapb=120.93n spba=121.82n spba1=124.403n dfm_flag=0 _ccoflag=1 _rcoflag=1 _rgflag=1 spmt=1.11111e+15 spomt=0 spomt1=1.11111e+60 spmb=1.11111e+15 spomb=0 spomb1=1.11111e+60
B6_SN0p (B6_h0p B6_ck0 B6_fp 0) nmos_lvt l=30n w=2u multi=1 nf=1 sd=100n ad=1.5e-13 as=1.5e-13 pd=4.15u ps=4.15u nrd=0.144730 nrs=0.144730 sa=75.0n sb=75.0n sa1=75.0n sa2=75.0n sa3=75.0n sa4=75.0n sb1=75.0n sb2=75.0n sb3=75.0n spa=100n spa1=100n spa2=100n spa3=100n sap=91.9776n sapb=114.444n spba=115.715n spba1=117.043n dfm_flag=0 _ccoflag=1 _rcoflag=1 _rgflag=1 spmt=1.11111e+15 spomt=0 spomt1=1.11111e+60 spmb=1.11111e+15 spomb=0 spomb1=1.11111e+60
B6_SP0p (B6_h0p B6_kb0 B6_fp bankvdd) pmos_lvt l=30n w=2u multi=1 nf=1 sd=100n ad=1.5e-13 as=1.5e-13 pd=4.15u ps=4.15u nrd=0.082877 nrs=0.082877 sa=75.0n sb=75.0n sa1=75.0n sa2=75.0n sa3=75.0n sa4=75.0n sb1=75.0n sb2=75.0n sb3=75.0n spa=100n spa1=100n spa2=100n spa3=100n sap=91.9776n sapb=114.444n spba=115.715n spba1=117.043n dfm_flag=0 _ccoflag=1 _rcoflag=1 _rgflag=1 spmt=1.11111e+15 spomt=0 spomt1=1.11111e+60 spmb=1.11111e+15 spomb=0 spomb1=1.11111e+60
B6_CH0p (B6_h0p 0) capacitor c=2.5e-14
B6_RH0p (B6_h0p B6_fp) resistor r=1T
B6_SN1p (B6_h1p B6_ck1 B6_fp 0) nmos_lvt l=30n w=2u multi=1 nf=1 sd=100n ad=1.5e-13 as=1.5e-13 pd=4.15u ps=4.15u nrd=0.144730 nrs=0.144730 sa=75.0n sb=75.0n sa1=75.0n sa2=75.0n sa3=75.0n sa4=75.0n sb1=75.0n sb2=75.0n sb3=75.0n spa=100n spa1=100n spa2=100n spa3=100n sap=91.9776n sapb=114.444n spba=115.715n spba1=117.043n dfm_flag=0 _ccoflag=1 _rcoflag=1 _rgflag=1 spmt=1.11111e+15 spomt=0 spomt1=1.11111e+60 spmb=1.11111e+15 spomb=0 spomb1=1.11111e+60
B6_SP1p (B6_h1p B6_kb1 B6_fp bankvdd) pmos_lvt l=30n w=2u multi=1 nf=1 sd=100n ad=1.5e-13 as=1.5e-13 pd=4.15u ps=4.15u nrd=0.082877 nrs=0.082877 sa=75.0n sb=75.0n sa1=75.0n sa2=75.0n sa3=75.0n sa4=75.0n sb1=75.0n sb2=75.0n sb3=75.0n spa=100n spa1=100n spa2=100n spa3=100n sap=91.9776n sapb=114.444n spba=115.715n spba1=117.043n dfm_flag=0 _ccoflag=1 _rcoflag=1 _rgflag=1 spmt=1.11111e+15 spomt=0 spomt1=1.11111e+60 spmb=1.11111e+15 spomb=0 spomb1=1.11111e+60
B6_CH1p (B6_h1p 0) capacitor c=2.5e-14
B6_RH1p (B6_h1p B6_fp) resistor r=1T
B6_SN2p (B6_h2p B6_ck2 B6_fp 0) nmos_lvt l=30n w=2u multi=1 nf=1 sd=100n ad=1.5e-13 as=1.5e-13 pd=4.15u ps=4.15u nrd=0.144730 nrs=0.144730 sa=75.0n sb=75.0n sa1=75.0n sa2=75.0n sa3=75.0n sa4=75.0n sb1=75.0n sb2=75.0n sb3=75.0n spa=100n spa1=100n spa2=100n spa3=100n sap=91.9776n sapb=114.444n spba=115.715n spba1=117.043n dfm_flag=0 _ccoflag=1 _rcoflag=1 _rgflag=1 spmt=1.11111e+15 spomt=0 spomt1=1.11111e+60 spmb=1.11111e+15 spomb=0 spomb1=1.11111e+60
B6_SP2p (B6_h2p B6_kb2 B6_fp bankvdd) pmos_lvt l=30n w=2u multi=1 nf=1 sd=100n ad=1.5e-13 as=1.5e-13 pd=4.15u ps=4.15u nrd=0.082877 nrs=0.082877 sa=75.0n sb=75.0n sa1=75.0n sa2=75.0n sa3=75.0n sa4=75.0n sb1=75.0n sb2=75.0n sb3=75.0n spa=100n spa1=100n spa2=100n spa3=100n sap=91.9776n sapb=114.444n spba=115.715n spba1=117.043n dfm_flag=0 _ccoflag=1 _rcoflag=1 _rgflag=1 spmt=1.11111e+15 spomt=0 spomt1=1.11111e+60 spmb=1.11111e+15 spomb=0 spomb1=1.11111e+60
B6_CH2p (B6_h2p 0) capacitor c=2.5e-14
B6_RH2p (B6_h2p B6_fp) resistor r=1T
B6_SN3p (B6_h3p B6_ck3 B6_fp 0) nmos_lvt l=30n w=2u multi=1 nf=1 sd=100n ad=1.5e-13 as=1.5e-13 pd=4.15u ps=4.15u nrd=0.144730 nrs=0.144730 sa=75.0n sb=75.0n sa1=75.0n sa2=75.0n sa3=75.0n sa4=75.0n sb1=75.0n sb2=75.0n sb3=75.0n spa=100n spa1=100n spa2=100n spa3=100n sap=91.9776n sapb=114.444n spba=115.715n spba1=117.043n dfm_flag=0 _ccoflag=1 _rcoflag=1 _rgflag=1 spmt=1.11111e+15 spomt=0 spomt1=1.11111e+60 spmb=1.11111e+15 spomb=0 spomb1=1.11111e+60
B6_SP3p (B6_h3p B6_kb3 B6_fp bankvdd) pmos_lvt l=30n w=2u multi=1 nf=1 sd=100n ad=1.5e-13 as=1.5e-13 pd=4.15u ps=4.15u nrd=0.082877 nrs=0.082877 sa=75.0n sb=75.0n sa1=75.0n sa2=75.0n sa3=75.0n sa4=75.0n sb1=75.0n sb2=75.0n sb3=75.0n spa=100n spa1=100n spa2=100n spa3=100n sap=91.9776n sapb=114.444n spba=115.715n spba1=117.043n dfm_flag=0 _ccoflag=1 _rcoflag=1 _rgflag=1 spmt=1.11111e+15 spomt=0 spomt1=1.11111e+60 spmb=1.11111e+15 spomb=0 spomb1=1.11111e+60
B6_CH3p (B6_h3p 0) capacitor c=2.5e-14
B6_RH3p (B6_h3p B6_fp) resistor r=1T
B6_SN4p (B6_h4p B6_ck4 B6_fp 0) nmos_lvt l=30n w=2u multi=1 nf=1 sd=100n ad=1.5e-13 as=1.5e-13 pd=4.15u ps=4.15u nrd=0.144730 nrs=0.144730 sa=75.0n sb=75.0n sa1=75.0n sa2=75.0n sa3=75.0n sa4=75.0n sb1=75.0n sb2=75.0n sb3=75.0n spa=100n spa1=100n spa2=100n spa3=100n sap=91.9776n sapb=114.444n spba=115.715n spba1=117.043n dfm_flag=0 _ccoflag=1 _rcoflag=1 _rgflag=1 spmt=1.11111e+15 spomt=0 spomt1=1.11111e+60 spmb=1.11111e+15 spomb=0 spomb1=1.11111e+60
B6_SP4p (B6_h4p B6_kb4 B6_fp bankvdd) pmos_lvt l=30n w=2u multi=1 nf=1 sd=100n ad=1.5e-13 as=1.5e-13 pd=4.15u ps=4.15u nrd=0.082877 nrs=0.082877 sa=75.0n sb=75.0n sa1=75.0n sa2=75.0n sa3=75.0n sa4=75.0n sb1=75.0n sb2=75.0n sb3=75.0n spa=100n spa1=100n spa2=100n spa3=100n sap=91.9776n sapb=114.444n spba=115.715n spba1=117.043n dfm_flag=0 _ccoflag=1 _rcoflag=1 _rgflag=1 spmt=1.11111e+15 spomt=0 spomt1=1.11111e+60 spmb=1.11111e+15 spomb=0 spomb1=1.11111e+60
B6_CH4p (B6_h4p 0) capacitor c=2.5e-14
B6_RH4p (B6_h4p B6_fp) resistor r=1T
B6_SN5p (B6_h5p B6_ck5 B6_fp 0) nmos_lvt l=30n w=2u multi=1 nf=1 sd=100n ad=1.5e-13 as=1.5e-13 pd=4.15u ps=4.15u nrd=0.144730 nrs=0.144730 sa=75.0n sb=75.0n sa1=75.0n sa2=75.0n sa3=75.0n sa4=75.0n sb1=75.0n sb2=75.0n sb3=75.0n spa=100n spa1=100n spa2=100n spa3=100n sap=91.9776n sapb=114.444n spba=115.715n spba1=117.043n dfm_flag=0 _ccoflag=1 _rcoflag=1 _rgflag=1 spmt=1.11111e+15 spomt=0 spomt1=1.11111e+60 spmb=1.11111e+15 spomb=0 spomb1=1.11111e+60
B6_SP5p (B6_h5p B6_kb5 B6_fp bankvdd) pmos_lvt l=30n w=2u multi=1 nf=1 sd=100n ad=1.5e-13 as=1.5e-13 pd=4.15u ps=4.15u nrd=0.082877 nrs=0.082877 sa=75.0n sb=75.0n sa1=75.0n sa2=75.0n sa3=75.0n sa4=75.0n sb1=75.0n sb2=75.0n sb3=75.0n spa=100n spa1=100n spa2=100n spa3=100n sap=91.9776n sapb=114.444n spba=115.715n spba1=117.043n dfm_flag=0 _ccoflag=1 _rcoflag=1 _rgflag=1 spmt=1.11111e+15 spomt=0 spomt1=1.11111e+60 spmb=1.11111e+15 spomb=0 spomb1=1.11111e+60
B6_CH5p (B6_h5p 0) capacitor c=2.5e-14
B6_RH5p (B6_h5p B6_fp) resistor r=1T
B6_SN6p (B6_h6p B6_ck6 B6_fp 0) nmos_lvt l=30n w=2u multi=1 nf=1 sd=100n ad=1.5e-13 as=1.5e-13 pd=4.15u ps=4.15u nrd=0.144730 nrs=0.144730 sa=75.0n sb=75.0n sa1=75.0n sa2=75.0n sa3=75.0n sa4=75.0n sb1=75.0n sb2=75.0n sb3=75.0n spa=100n spa1=100n spa2=100n spa3=100n sap=91.9776n sapb=114.444n spba=115.715n spba1=117.043n dfm_flag=0 _ccoflag=1 _rcoflag=1 _rgflag=1 spmt=1.11111e+15 spomt=0 spomt1=1.11111e+60 spmb=1.11111e+15 spomb=0 spomb1=1.11111e+60
B6_SP6p (B6_h6p B6_kb6 B6_fp bankvdd) pmos_lvt l=30n w=2u multi=1 nf=1 sd=100n ad=1.5e-13 as=1.5e-13 pd=4.15u ps=4.15u nrd=0.082877 nrs=0.082877 sa=75.0n sb=75.0n sa1=75.0n sa2=75.0n sa3=75.0n sa4=75.0n sb1=75.0n sb2=75.0n sb3=75.0n spa=100n spa1=100n spa2=100n spa3=100n sap=91.9776n sapb=114.444n spba=115.715n spba1=117.043n dfm_flag=0 _ccoflag=1 _rcoflag=1 _rgflag=1 spmt=1.11111e+15 spomt=0 spomt1=1.11111e+60 spmb=1.11111e+15 spomb=0 spomb1=1.11111e+60
B6_CH6p (B6_h6p 0) capacitor c=2.5e-14
B6_RH6p (B6_h6p B6_fp) resistor r=1T
B6_SN7p (B6_h7p B6_ck7 B6_fp 0) nmos_lvt l=30n w=2u multi=1 nf=1 sd=100n ad=1.5e-13 as=1.5e-13 pd=4.15u ps=4.15u nrd=0.144730 nrs=0.144730 sa=75.0n sb=75.0n sa1=75.0n sa2=75.0n sa3=75.0n sa4=75.0n sb1=75.0n sb2=75.0n sb3=75.0n spa=100n spa1=100n spa2=100n spa3=100n sap=91.9776n sapb=114.444n spba=115.715n spba1=117.043n dfm_flag=0 _ccoflag=1 _rcoflag=1 _rgflag=1 spmt=1.11111e+15 spomt=0 spomt1=1.11111e+60 spmb=1.11111e+15 spomb=0 spomb1=1.11111e+60
B6_SP7p (B6_h7p B6_kb7 B6_fp bankvdd) pmos_lvt l=30n w=2u multi=1 nf=1 sd=100n ad=1.5e-13 as=1.5e-13 pd=4.15u ps=4.15u nrd=0.082877 nrs=0.082877 sa=75.0n sb=75.0n sa1=75.0n sa2=75.0n sa3=75.0n sa4=75.0n sb1=75.0n sb2=75.0n sb3=75.0n spa=100n spa1=100n spa2=100n spa3=100n sap=91.9776n sapb=114.444n spba=115.715n spba1=117.043n dfm_flag=0 _ccoflag=1 _rcoflag=1 _rgflag=1 spmt=1.11111e+15 spomt=0 spomt1=1.11111e+60 spmb=1.11111e+15 spomb=0 spomb1=1.11111e+60
B6_CH7p (B6_h7p 0) capacitor c=2.5e-14
B6_RH7p (B6_h7p B6_fp) resistor r=1T
RB6_Lm (bankvdd B6_fm) resistor r=500
B6_Fm (B6_fm X_h6m B6_em 0) nmos_lvt l=30n w=2u multi=1 nf=1 sd=100n ad=1.5e-13 as=1.5e-13 pd=4.15u ps=4.15u nrd=0.144730 nrs=0.144730 sa=75.0n sb=75.0n sa1=75.0n sa2=75.0n sa3=75.0n sa4=75.0n sb1=75.0n sb2=75.0n sb3=75.0n spa=100n spa1=100n spa2=100n spa3=100n sap=91.9776n sapb=114.444n spba=115.715n spba1=117.043n dfm_flag=0 _ccoflag=1 _rcoflag=1 _rgflag=1 spmt=1.11111e+15 spomt=0 spomt1=1.11111e+60 spmb=1.11111e+15 spomb=0 spomb1=1.11111e+60
B6_Tm (B6_em nbias 0 0) nmos_lvt l=60n w=2u multi=1 nf=1 sd=100n ad=1.5e-13 as=1.5e-13 pd=4.15u ps=4.15u nrd=0.144730 nrs=0.144730 sa=75.0n sb=75.0n sa1=75.0n sa2=75.0n sa3=75.0n sa4=75.0n sb1=75.0n sb2=75.0n sb3=75.0n spa=100n spa1=100n spa2=100n spa3=100n sap=91.9776n sapb=120.93n spba=121.82n spba1=124.403n dfm_flag=0 _ccoflag=1 _rcoflag=1 _rgflag=1 spmt=1.11111e+15 spomt=0 spomt1=1.11111e+60 spmb=1.11111e+15 spomb=0 spomb1=1.11111e+60
B6_SN0m (B6_h0m B6_ck0 B6_fm 0) nmos_lvt l=30n w=2u multi=1 nf=1 sd=100n ad=1.5e-13 as=1.5e-13 pd=4.15u ps=4.15u nrd=0.144730 nrs=0.144730 sa=75.0n sb=75.0n sa1=75.0n sa2=75.0n sa3=75.0n sa4=75.0n sb1=75.0n sb2=75.0n sb3=75.0n spa=100n spa1=100n spa2=100n spa3=100n sap=91.9776n sapb=114.444n spba=115.715n spba1=117.043n dfm_flag=0 _ccoflag=1 _rcoflag=1 _rgflag=1 spmt=1.11111e+15 spomt=0 spomt1=1.11111e+60 spmb=1.11111e+15 spomb=0 spomb1=1.11111e+60
B6_SP0m (B6_h0m B6_kb0 B6_fm bankvdd) pmos_lvt l=30n w=2u multi=1 nf=1 sd=100n ad=1.5e-13 as=1.5e-13 pd=4.15u ps=4.15u nrd=0.082877 nrs=0.082877 sa=75.0n sb=75.0n sa1=75.0n sa2=75.0n sa3=75.0n sa4=75.0n sb1=75.0n sb2=75.0n sb3=75.0n spa=100n spa1=100n spa2=100n spa3=100n sap=91.9776n sapb=114.444n spba=115.715n spba1=117.043n dfm_flag=0 _ccoflag=1 _rcoflag=1 _rgflag=1 spmt=1.11111e+15 spomt=0 spomt1=1.11111e+60 spmb=1.11111e+15 spomb=0 spomb1=1.11111e+60
B6_CH0m (B6_h0m 0) capacitor c=2.5e-14
B6_RH0m (B6_h0m B6_fm) resistor r=1T
B6_SN1m (B6_h1m B6_ck1 B6_fm 0) nmos_lvt l=30n w=2u multi=1 nf=1 sd=100n ad=1.5e-13 as=1.5e-13 pd=4.15u ps=4.15u nrd=0.144730 nrs=0.144730 sa=75.0n sb=75.0n sa1=75.0n sa2=75.0n sa3=75.0n sa4=75.0n sb1=75.0n sb2=75.0n sb3=75.0n spa=100n spa1=100n spa2=100n spa3=100n sap=91.9776n sapb=114.444n spba=115.715n spba1=117.043n dfm_flag=0 _ccoflag=1 _rcoflag=1 _rgflag=1 spmt=1.11111e+15 spomt=0 spomt1=1.11111e+60 spmb=1.11111e+15 spomb=0 spomb1=1.11111e+60
B6_SP1m (B6_h1m B6_kb1 B6_fm bankvdd) pmos_lvt l=30n w=2u multi=1 nf=1 sd=100n ad=1.5e-13 as=1.5e-13 pd=4.15u ps=4.15u nrd=0.082877 nrs=0.082877 sa=75.0n sb=75.0n sa1=75.0n sa2=75.0n sa3=75.0n sa4=75.0n sb1=75.0n sb2=75.0n sb3=75.0n spa=100n spa1=100n spa2=100n spa3=100n sap=91.9776n sapb=114.444n spba=115.715n spba1=117.043n dfm_flag=0 _ccoflag=1 _rcoflag=1 _rgflag=1 spmt=1.11111e+15 spomt=0 spomt1=1.11111e+60 spmb=1.11111e+15 spomb=0 spomb1=1.11111e+60
B6_CH1m (B6_h1m 0) capacitor c=2.5e-14
B6_RH1m (B6_h1m B6_fm) resistor r=1T
B6_SN2m (B6_h2m B6_ck2 B6_fm 0) nmos_lvt l=30n w=2u multi=1 nf=1 sd=100n ad=1.5e-13 as=1.5e-13 pd=4.15u ps=4.15u nrd=0.144730 nrs=0.144730 sa=75.0n sb=75.0n sa1=75.0n sa2=75.0n sa3=75.0n sa4=75.0n sb1=75.0n sb2=75.0n sb3=75.0n spa=100n spa1=100n spa2=100n spa3=100n sap=91.9776n sapb=114.444n spba=115.715n spba1=117.043n dfm_flag=0 _ccoflag=1 _rcoflag=1 _rgflag=1 spmt=1.11111e+15 spomt=0 spomt1=1.11111e+60 spmb=1.11111e+15 spomb=0 spomb1=1.11111e+60
B6_SP2m (B6_h2m B6_kb2 B6_fm bankvdd) pmos_lvt l=30n w=2u multi=1 nf=1 sd=100n ad=1.5e-13 as=1.5e-13 pd=4.15u ps=4.15u nrd=0.082877 nrs=0.082877 sa=75.0n sb=75.0n sa1=75.0n sa2=75.0n sa3=75.0n sa4=75.0n sb1=75.0n sb2=75.0n sb3=75.0n spa=100n spa1=100n spa2=100n spa3=100n sap=91.9776n sapb=114.444n spba=115.715n spba1=117.043n dfm_flag=0 _ccoflag=1 _rcoflag=1 _rgflag=1 spmt=1.11111e+15 spomt=0 spomt1=1.11111e+60 spmb=1.11111e+15 spomb=0 spomb1=1.11111e+60
B6_CH2m (B6_h2m 0) capacitor c=2.5e-14
B6_RH2m (B6_h2m B6_fm) resistor r=1T
B6_SN3m (B6_h3m B6_ck3 B6_fm 0) nmos_lvt l=30n w=2u multi=1 nf=1 sd=100n ad=1.5e-13 as=1.5e-13 pd=4.15u ps=4.15u nrd=0.144730 nrs=0.144730 sa=75.0n sb=75.0n sa1=75.0n sa2=75.0n sa3=75.0n sa4=75.0n sb1=75.0n sb2=75.0n sb3=75.0n spa=100n spa1=100n spa2=100n spa3=100n sap=91.9776n sapb=114.444n spba=115.715n spba1=117.043n dfm_flag=0 _ccoflag=1 _rcoflag=1 _rgflag=1 spmt=1.11111e+15 spomt=0 spomt1=1.11111e+60 spmb=1.11111e+15 spomb=0 spomb1=1.11111e+60
B6_SP3m (B6_h3m B6_kb3 B6_fm bankvdd) pmos_lvt l=30n w=2u multi=1 nf=1 sd=100n ad=1.5e-13 as=1.5e-13 pd=4.15u ps=4.15u nrd=0.082877 nrs=0.082877 sa=75.0n sb=75.0n sa1=75.0n sa2=75.0n sa3=75.0n sa4=75.0n sb1=75.0n sb2=75.0n sb3=75.0n spa=100n spa1=100n spa2=100n spa3=100n sap=91.9776n sapb=114.444n spba=115.715n spba1=117.043n dfm_flag=0 _ccoflag=1 _rcoflag=1 _rgflag=1 spmt=1.11111e+15 spomt=0 spomt1=1.11111e+60 spmb=1.11111e+15 spomb=0 spomb1=1.11111e+60
B6_CH3m (B6_h3m 0) capacitor c=2.5e-14
B6_RH3m (B6_h3m B6_fm) resistor r=1T
B6_SN4m (B6_h4m B6_ck4 B6_fm 0) nmos_lvt l=30n w=2u multi=1 nf=1 sd=100n ad=1.5e-13 as=1.5e-13 pd=4.15u ps=4.15u nrd=0.144730 nrs=0.144730 sa=75.0n sb=75.0n sa1=75.0n sa2=75.0n sa3=75.0n sa4=75.0n sb1=75.0n sb2=75.0n sb3=75.0n spa=100n spa1=100n spa2=100n spa3=100n sap=91.9776n sapb=114.444n spba=115.715n spba1=117.043n dfm_flag=0 _ccoflag=1 _rcoflag=1 _rgflag=1 spmt=1.11111e+15 spomt=0 spomt1=1.11111e+60 spmb=1.11111e+15 spomb=0 spomb1=1.11111e+60
B6_SP4m (B6_h4m B6_kb4 B6_fm bankvdd) pmos_lvt l=30n w=2u multi=1 nf=1 sd=100n ad=1.5e-13 as=1.5e-13 pd=4.15u ps=4.15u nrd=0.082877 nrs=0.082877 sa=75.0n sb=75.0n sa1=75.0n sa2=75.0n sa3=75.0n sa4=75.0n sb1=75.0n sb2=75.0n sb3=75.0n spa=100n spa1=100n spa2=100n spa3=100n sap=91.9776n sapb=114.444n spba=115.715n spba1=117.043n dfm_flag=0 _ccoflag=1 _rcoflag=1 _rgflag=1 spmt=1.11111e+15 spomt=0 spomt1=1.11111e+60 spmb=1.11111e+15 spomb=0 spomb1=1.11111e+60
B6_CH4m (B6_h4m 0) capacitor c=2.5e-14
B6_RH4m (B6_h4m B6_fm) resistor r=1T
B6_SN5m (B6_h5m B6_ck5 B6_fm 0) nmos_lvt l=30n w=2u multi=1 nf=1 sd=100n ad=1.5e-13 as=1.5e-13 pd=4.15u ps=4.15u nrd=0.144730 nrs=0.144730 sa=75.0n sb=75.0n sa1=75.0n sa2=75.0n sa3=75.0n sa4=75.0n sb1=75.0n sb2=75.0n sb3=75.0n spa=100n spa1=100n spa2=100n spa3=100n sap=91.9776n sapb=114.444n spba=115.715n spba1=117.043n dfm_flag=0 _ccoflag=1 _rcoflag=1 _rgflag=1 spmt=1.11111e+15 spomt=0 spomt1=1.11111e+60 spmb=1.11111e+15 spomb=0 spomb1=1.11111e+60
B6_SP5m (B6_h5m B6_kb5 B6_fm bankvdd) pmos_lvt l=30n w=2u multi=1 nf=1 sd=100n ad=1.5e-13 as=1.5e-13 pd=4.15u ps=4.15u nrd=0.082877 nrs=0.082877 sa=75.0n sb=75.0n sa1=75.0n sa2=75.0n sa3=75.0n sa4=75.0n sb1=75.0n sb2=75.0n sb3=75.0n spa=100n spa1=100n spa2=100n spa3=100n sap=91.9776n sapb=114.444n spba=115.715n spba1=117.043n dfm_flag=0 _ccoflag=1 _rcoflag=1 _rgflag=1 spmt=1.11111e+15 spomt=0 spomt1=1.11111e+60 spmb=1.11111e+15 spomb=0 spomb1=1.11111e+60
B6_CH5m (B6_h5m 0) capacitor c=2.5e-14
B6_RH5m (B6_h5m B6_fm) resistor r=1T
B6_SN6m (B6_h6m B6_ck6 B6_fm 0) nmos_lvt l=30n w=2u multi=1 nf=1 sd=100n ad=1.5e-13 as=1.5e-13 pd=4.15u ps=4.15u nrd=0.144730 nrs=0.144730 sa=75.0n sb=75.0n sa1=75.0n sa2=75.0n sa3=75.0n sa4=75.0n sb1=75.0n sb2=75.0n sb3=75.0n spa=100n spa1=100n spa2=100n spa3=100n sap=91.9776n sapb=114.444n spba=115.715n spba1=117.043n dfm_flag=0 _ccoflag=1 _rcoflag=1 _rgflag=1 spmt=1.11111e+15 spomt=0 spomt1=1.11111e+60 spmb=1.11111e+15 spomb=0 spomb1=1.11111e+60
B6_SP6m (B6_h6m B6_kb6 B6_fm bankvdd) pmos_lvt l=30n w=2u multi=1 nf=1 sd=100n ad=1.5e-13 as=1.5e-13 pd=4.15u ps=4.15u nrd=0.082877 nrs=0.082877 sa=75.0n sb=75.0n sa1=75.0n sa2=75.0n sa3=75.0n sa4=75.0n sb1=75.0n sb2=75.0n sb3=75.0n spa=100n spa1=100n spa2=100n spa3=100n sap=91.9776n sapb=114.444n spba=115.715n spba1=117.043n dfm_flag=0 _ccoflag=1 _rcoflag=1 _rgflag=1 spmt=1.11111e+15 spomt=0 spomt1=1.11111e+60 spmb=1.11111e+15 spomb=0 spomb1=1.11111e+60
B6_CH6m (B6_h6m 0) capacitor c=2.5e-14
B6_RH6m (B6_h6m B6_fm) resistor r=1T
B6_SN7m (B6_h7m B6_ck7 B6_fm 0) nmos_lvt l=30n w=2u multi=1 nf=1 sd=100n ad=1.5e-13 as=1.5e-13 pd=4.15u ps=4.15u nrd=0.144730 nrs=0.144730 sa=75.0n sb=75.0n sa1=75.0n sa2=75.0n sa3=75.0n sa4=75.0n sb1=75.0n sb2=75.0n sb3=75.0n spa=100n spa1=100n spa2=100n spa3=100n sap=91.9776n sapb=114.444n spba=115.715n spba1=117.043n dfm_flag=0 _ccoflag=1 _rcoflag=1 _rgflag=1 spmt=1.11111e+15 spomt=0 spomt1=1.11111e+60 spmb=1.11111e+15 spomb=0 spomb1=1.11111e+60
B6_SP7m (B6_h7m B6_kb7 B6_fm bankvdd) pmos_lvt l=30n w=2u multi=1 nf=1 sd=100n ad=1.5e-13 as=1.5e-13 pd=4.15u ps=4.15u nrd=0.082877 nrs=0.082877 sa=75.0n sb=75.0n sa1=75.0n sa2=75.0n sa3=75.0n sa4=75.0n sb1=75.0n sb2=75.0n sb3=75.0n spa=100n spa1=100n spa2=100n spa3=100n sap=91.9776n sapb=114.444n spba=115.715n spba1=117.043n dfm_flag=0 _ccoflag=1 _rcoflag=1 _rgflag=1 spmt=1.11111e+15 spomt=0 spomt1=1.11111e+60 spmb=1.11111e+15 spomb=0 spomb1=1.11111e+60
B6_CH7m (B6_h7m 0) capacitor c=2.5e-14
B6_RH7m (B6_h7m B6_fm) resistor r=1T
B6_RDEG (B6_ep B6_em) resistor r=250
B6_COMP0 (B6_h0p B6_h0m compvdd logicvdd) COMPLOAD
B6_COMP1 (B6_h1p B6_h1m compvdd logicvdd) COMPLOAD
B6_COMP2 (B6_h2p B6_h2m compvdd logicvdd) COMPLOAD
B6_COMP3 (B6_h3p B6_h3m compvdd logicvdd) COMPLOAD
B6_COMP4 (B6_h4p B6_h4m compvdd logicvdd) COMPLOAD
B6_COMP5 (B6_h5p B6_h5m compvdd logicvdd) COMPLOAD
B6_COMP6 (B6_h6p B6_h6m compvdd logicvdd) COMPLOAD
B6_COMP7 (B6_h7p B6_h7m compvdd logicvdd) COMPLOAD
B7_ck0V (B7_ck0 0) vsource type=pulse val0=0 val1=0.9 delay=1.667321428571429e-10 rise=1e-12 fall=1e-12 width=6.471429999999999e-11 period=5.714288e-10
B7_kb0V (B7_kb0 0) vsource type=pulse val0=0.9 val1=0 delay=1.667321428571429e-10 rise=1e-12 fall=1e-12 width=6.471429999999999e-11 period=5.714288e-10
B7_ck1V (B7_ck1 0) vsource type=pulse val0=0 val1=0.9 delay=2.381607428571429e-10 rise=1e-12 fall=1e-12 width=6.471429999999999e-11 period=5.714288e-10
B7_kb1V (B7_kb1 0) vsource type=pulse val0=0.9 val1=0 delay=2.381607428571429e-10 rise=1e-12 fall=1e-12 width=6.471429999999999e-11 period=5.714288e-10
B7_ck2V (B7_ck2 0) vsource type=pulse val0=0 val1=0.9 delay=3.095893428571429e-10 rise=1e-12 fall=1e-12 width=6.471429999999999e-11 period=5.714288e-10
B7_kb2V (B7_kb2 0) vsource type=pulse val0=0.9 val1=0 delay=3.095893428571429e-10 rise=1e-12 fall=1e-12 width=6.471429999999999e-11 period=5.714288e-10
B7_ck3V (B7_ck3 0) vsource type=pulse val0=0 val1=0.9 delay=3.810179428571429e-10 rise=1e-12 fall=1e-12 width=6.471429999999999e-11 period=5.714288e-10
B7_kb3V (B7_kb3 0) vsource type=pulse val0=0.9 val1=0 delay=3.810179428571429e-10 rise=1e-12 fall=1e-12 width=6.471429999999999e-11 period=5.714288e-10
B7_ck4V (B7_ck4 0) vsource type=pulse val0=0 val1=0.9 delay=4.524465428571429e-10 rise=1e-12 fall=1e-12 width=6.471429999999999e-11 period=5.714288e-10
B7_kb4V (B7_kb4 0) vsource type=pulse val0=0.9 val1=0 delay=4.524465428571429e-10 rise=1e-12 fall=1e-12 width=6.471429999999999e-11 period=5.714288e-10
B7_ck5V (B7_ck5 0) vsource type=pulse val0=0 val1=0.9 delay=5.238751428571429e-10 rise=1e-12 fall=1e-12 width=6.471429999999999e-11 period=5.714288e-10
B7_kb5V (B7_kb5 0) vsource type=pulse val0=0.9 val1=0 delay=5.238751428571429e-10 rise=1e-12 fall=1e-12 width=6.471429999999999e-11 period=5.714288e-10
B7_ck6V (B7_ck6 0) vsource type=pulse val0=0 val1=0.9 delay=5.953037428571429e-10 rise=1e-12 fall=1e-12 width=6.471429999999999e-11 period=5.714288e-10
B7_kb6V (B7_kb6 0) vsource type=pulse val0=0.9 val1=0 delay=5.953037428571429e-10 rise=1e-12 fall=1e-12 width=6.471429999999999e-11 period=5.714288e-10
B7_ck7V (B7_ck7 0) vsource type=pulse val0=0 val1=0.9 delay=6.667323428571429e-10 rise=1e-12 fall=1e-12 width=6.471429999999999e-11 period=5.714288e-10
B7_kb7V (B7_kb7 0) vsource type=pulse val0=0.9 val1=0 delay=6.667323428571429e-10 rise=1e-12 fall=1e-12 width=6.471429999999999e-11 period=5.714288e-10
RB7_Lp (bankvdd B7_fp) resistor r=500
B7_Fp (B7_fp X_h7p B7_ep 0) nmos_lvt l=30n w=2u multi=1 nf=1 sd=100n ad=1.5e-13 as=1.5e-13 pd=4.15u ps=4.15u nrd=0.144730 nrs=0.144730 sa=75.0n sb=75.0n sa1=75.0n sa2=75.0n sa3=75.0n sa4=75.0n sb1=75.0n sb2=75.0n sb3=75.0n spa=100n spa1=100n spa2=100n spa3=100n sap=91.9776n sapb=114.444n spba=115.715n spba1=117.043n dfm_flag=0 _ccoflag=1 _rcoflag=1 _rgflag=1 spmt=1.11111e+15 spomt=0 spomt1=1.11111e+60 spmb=1.11111e+15 spomb=0 spomb1=1.11111e+60
B7_Tp (B7_ep nbias 0 0) nmos_lvt l=60n w=2u multi=1 nf=1 sd=100n ad=1.5e-13 as=1.5e-13 pd=4.15u ps=4.15u nrd=0.144730 nrs=0.144730 sa=75.0n sb=75.0n sa1=75.0n sa2=75.0n sa3=75.0n sa4=75.0n sb1=75.0n sb2=75.0n sb3=75.0n spa=100n spa1=100n spa2=100n spa3=100n sap=91.9776n sapb=120.93n spba=121.82n spba1=124.403n dfm_flag=0 _ccoflag=1 _rcoflag=1 _rgflag=1 spmt=1.11111e+15 spomt=0 spomt1=1.11111e+60 spmb=1.11111e+15 spomb=0 spomb1=1.11111e+60
B7_SN0p (B7_h0p B7_ck0 B7_fp 0) nmos_lvt l=30n w=2u multi=1 nf=1 sd=100n ad=1.5e-13 as=1.5e-13 pd=4.15u ps=4.15u nrd=0.144730 nrs=0.144730 sa=75.0n sb=75.0n sa1=75.0n sa2=75.0n sa3=75.0n sa4=75.0n sb1=75.0n sb2=75.0n sb3=75.0n spa=100n spa1=100n spa2=100n spa3=100n sap=91.9776n sapb=114.444n spba=115.715n spba1=117.043n dfm_flag=0 _ccoflag=1 _rcoflag=1 _rgflag=1 spmt=1.11111e+15 spomt=0 spomt1=1.11111e+60 spmb=1.11111e+15 spomb=0 spomb1=1.11111e+60
B7_SP0p (B7_h0p B7_kb0 B7_fp bankvdd) pmos_lvt l=30n w=2u multi=1 nf=1 sd=100n ad=1.5e-13 as=1.5e-13 pd=4.15u ps=4.15u nrd=0.082877 nrs=0.082877 sa=75.0n sb=75.0n sa1=75.0n sa2=75.0n sa3=75.0n sa4=75.0n sb1=75.0n sb2=75.0n sb3=75.0n spa=100n spa1=100n spa2=100n spa3=100n sap=91.9776n sapb=114.444n spba=115.715n spba1=117.043n dfm_flag=0 _ccoflag=1 _rcoflag=1 _rgflag=1 spmt=1.11111e+15 spomt=0 spomt1=1.11111e+60 spmb=1.11111e+15 spomb=0 spomb1=1.11111e+60
B7_CH0p (B7_h0p 0) capacitor c=2.5e-14
B7_RH0p (B7_h0p B7_fp) resistor r=1T
B7_SN1p (B7_h1p B7_ck1 B7_fp 0) nmos_lvt l=30n w=2u multi=1 nf=1 sd=100n ad=1.5e-13 as=1.5e-13 pd=4.15u ps=4.15u nrd=0.144730 nrs=0.144730 sa=75.0n sb=75.0n sa1=75.0n sa2=75.0n sa3=75.0n sa4=75.0n sb1=75.0n sb2=75.0n sb3=75.0n spa=100n spa1=100n spa2=100n spa3=100n sap=91.9776n sapb=114.444n spba=115.715n spba1=117.043n dfm_flag=0 _ccoflag=1 _rcoflag=1 _rgflag=1 spmt=1.11111e+15 spomt=0 spomt1=1.11111e+60 spmb=1.11111e+15 spomb=0 spomb1=1.11111e+60
B7_SP1p (B7_h1p B7_kb1 B7_fp bankvdd) pmos_lvt l=30n w=2u multi=1 nf=1 sd=100n ad=1.5e-13 as=1.5e-13 pd=4.15u ps=4.15u nrd=0.082877 nrs=0.082877 sa=75.0n sb=75.0n sa1=75.0n sa2=75.0n sa3=75.0n sa4=75.0n sb1=75.0n sb2=75.0n sb3=75.0n spa=100n spa1=100n spa2=100n spa3=100n sap=91.9776n sapb=114.444n spba=115.715n spba1=117.043n dfm_flag=0 _ccoflag=1 _rcoflag=1 _rgflag=1 spmt=1.11111e+15 spomt=0 spomt1=1.11111e+60 spmb=1.11111e+15 spomb=0 spomb1=1.11111e+60
B7_CH1p (B7_h1p 0) capacitor c=2.5e-14
B7_RH1p (B7_h1p B7_fp) resistor r=1T
B7_SN2p (B7_h2p B7_ck2 B7_fp 0) nmos_lvt l=30n w=2u multi=1 nf=1 sd=100n ad=1.5e-13 as=1.5e-13 pd=4.15u ps=4.15u nrd=0.144730 nrs=0.144730 sa=75.0n sb=75.0n sa1=75.0n sa2=75.0n sa3=75.0n sa4=75.0n sb1=75.0n sb2=75.0n sb3=75.0n spa=100n spa1=100n spa2=100n spa3=100n sap=91.9776n sapb=114.444n spba=115.715n spba1=117.043n dfm_flag=0 _ccoflag=1 _rcoflag=1 _rgflag=1 spmt=1.11111e+15 spomt=0 spomt1=1.11111e+60 spmb=1.11111e+15 spomb=0 spomb1=1.11111e+60
B7_SP2p (B7_h2p B7_kb2 B7_fp bankvdd) pmos_lvt l=30n w=2u multi=1 nf=1 sd=100n ad=1.5e-13 as=1.5e-13 pd=4.15u ps=4.15u nrd=0.082877 nrs=0.082877 sa=75.0n sb=75.0n sa1=75.0n sa2=75.0n sa3=75.0n sa4=75.0n sb1=75.0n sb2=75.0n sb3=75.0n spa=100n spa1=100n spa2=100n spa3=100n sap=91.9776n sapb=114.444n spba=115.715n spba1=117.043n dfm_flag=0 _ccoflag=1 _rcoflag=1 _rgflag=1 spmt=1.11111e+15 spomt=0 spomt1=1.11111e+60 spmb=1.11111e+15 spomb=0 spomb1=1.11111e+60
B7_CH2p (B7_h2p 0) capacitor c=2.5e-14
B7_RH2p (B7_h2p B7_fp) resistor r=1T
B7_SN3p (B7_h3p B7_ck3 B7_fp 0) nmos_lvt l=30n w=2u multi=1 nf=1 sd=100n ad=1.5e-13 as=1.5e-13 pd=4.15u ps=4.15u nrd=0.144730 nrs=0.144730 sa=75.0n sb=75.0n sa1=75.0n sa2=75.0n sa3=75.0n sa4=75.0n sb1=75.0n sb2=75.0n sb3=75.0n spa=100n spa1=100n spa2=100n spa3=100n sap=91.9776n sapb=114.444n spba=115.715n spba1=117.043n dfm_flag=0 _ccoflag=1 _rcoflag=1 _rgflag=1 spmt=1.11111e+15 spomt=0 spomt1=1.11111e+60 spmb=1.11111e+15 spomb=0 spomb1=1.11111e+60
B7_SP3p (B7_h3p B7_kb3 B7_fp bankvdd) pmos_lvt l=30n w=2u multi=1 nf=1 sd=100n ad=1.5e-13 as=1.5e-13 pd=4.15u ps=4.15u nrd=0.082877 nrs=0.082877 sa=75.0n sb=75.0n sa1=75.0n sa2=75.0n sa3=75.0n sa4=75.0n sb1=75.0n sb2=75.0n sb3=75.0n spa=100n spa1=100n spa2=100n spa3=100n sap=91.9776n sapb=114.444n spba=115.715n spba1=117.043n dfm_flag=0 _ccoflag=1 _rcoflag=1 _rgflag=1 spmt=1.11111e+15 spomt=0 spomt1=1.11111e+60 spmb=1.11111e+15 spomb=0 spomb1=1.11111e+60
B7_CH3p (B7_h3p 0) capacitor c=2.5e-14
B7_RH3p (B7_h3p B7_fp) resistor r=1T
B7_SN4p (B7_h4p B7_ck4 B7_fp 0) nmos_lvt l=30n w=2u multi=1 nf=1 sd=100n ad=1.5e-13 as=1.5e-13 pd=4.15u ps=4.15u nrd=0.144730 nrs=0.144730 sa=75.0n sb=75.0n sa1=75.0n sa2=75.0n sa3=75.0n sa4=75.0n sb1=75.0n sb2=75.0n sb3=75.0n spa=100n spa1=100n spa2=100n spa3=100n sap=91.9776n sapb=114.444n spba=115.715n spba1=117.043n dfm_flag=0 _ccoflag=1 _rcoflag=1 _rgflag=1 spmt=1.11111e+15 spomt=0 spomt1=1.11111e+60 spmb=1.11111e+15 spomb=0 spomb1=1.11111e+60
B7_SP4p (B7_h4p B7_kb4 B7_fp bankvdd) pmos_lvt l=30n w=2u multi=1 nf=1 sd=100n ad=1.5e-13 as=1.5e-13 pd=4.15u ps=4.15u nrd=0.082877 nrs=0.082877 sa=75.0n sb=75.0n sa1=75.0n sa2=75.0n sa3=75.0n sa4=75.0n sb1=75.0n sb2=75.0n sb3=75.0n spa=100n spa1=100n spa2=100n spa3=100n sap=91.9776n sapb=114.444n spba=115.715n spba1=117.043n dfm_flag=0 _ccoflag=1 _rcoflag=1 _rgflag=1 spmt=1.11111e+15 spomt=0 spomt1=1.11111e+60 spmb=1.11111e+15 spomb=0 spomb1=1.11111e+60
B7_CH4p (B7_h4p 0) capacitor c=2.5e-14
B7_RH4p (B7_h4p B7_fp) resistor r=1T
B7_SN5p (B7_h5p B7_ck5 B7_fp 0) nmos_lvt l=30n w=2u multi=1 nf=1 sd=100n ad=1.5e-13 as=1.5e-13 pd=4.15u ps=4.15u nrd=0.144730 nrs=0.144730 sa=75.0n sb=75.0n sa1=75.0n sa2=75.0n sa3=75.0n sa4=75.0n sb1=75.0n sb2=75.0n sb3=75.0n spa=100n spa1=100n spa2=100n spa3=100n sap=91.9776n sapb=114.444n spba=115.715n spba1=117.043n dfm_flag=0 _ccoflag=1 _rcoflag=1 _rgflag=1 spmt=1.11111e+15 spomt=0 spomt1=1.11111e+60 spmb=1.11111e+15 spomb=0 spomb1=1.11111e+60
B7_SP5p (B7_h5p B7_kb5 B7_fp bankvdd) pmos_lvt l=30n w=2u multi=1 nf=1 sd=100n ad=1.5e-13 as=1.5e-13 pd=4.15u ps=4.15u nrd=0.082877 nrs=0.082877 sa=75.0n sb=75.0n sa1=75.0n sa2=75.0n sa3=75.0n sa4=75.0n sb1=75.0n sb2=75.0n sb3=75.0n spa=100n spa1=100n spa2=100n spa3=100n sap=91.9776n sapb=114.444n spba=115.715n spba1=117.043n dfm_flag=0 _ccoflag=1 _rcoflag=1 _rgflag=1 spmt=1.11111e+15 spomt=0 spomt1=1.11111e+60 spmb=1.11111e+15 spomb=0 spomb1=1.11111e+60
B7_CH5p (B7_h5p 0) capacitor c=2.5e-14
B7_RH5p (B7_h5p B7_fp) resistor r=1T
B7_SN6p (B7_h6p B7_ck6 B7_fp 0) nmos_lvt l=30n w=2u multi=1 nf=1 sd=100n ad=1.5e-13 as=1.5e-13 pd=4.15u ps=4.15u nrd=0.144730 nrs=0.144730 sa=75.0n sb=75.0n sa1=75.0n sa2=75.0n sa3=75.0n sa4=75.0n sb1=75.0n sb2=75.0n sb3=75.0n spa=100n spa1=100n spa2=100n spa3=100n sap=91.9776n sapb=114.444n spba=115.715n spba1=117.043n dfm_flag=0 _ccoflag=1 _rcoflag=1 _rgflag=1 spmt=1.11111e+15 spomt=0 spomt1=1.11111e+60 spmb=1.11111e+15 spomb=0 spomb1=1.11111e+60
B7_SP6p (B7_h6p B7_kb6 B7_fp bankvdd) pmos_lvt l=30n w=2u multi=1 nf=1 sd=100n ad=1.5e-13 as=1.5e-13 pd=4.15u ps=4.15u nrd=0.082877 nrs=0.082877 sa=75.0n sb=75.0n sa1=75.0n sa2=75.0n sa3=75.0n sa4=75.0n sb1=75.0n sb2=75.0n sb3=75.0n spa=100n spa1=100n spa2=100n spa3=100n sap=91.9776n sapb=114.444n spba=115.715n spba1=117.043n dfm_flag=0 _ccoflag=1 _rcoflag=1 _rgflag=1 spmt=1.11111e+15 spomt=0 spomt1=1.11111e+60 spmb=1.11111e+15 spomb=0 spomb1=1.11111e+60
B7_CH6p (B7_h6p 0) capacitor c=2.5e-14
B7_RH6p (B7_h6p B7_fp) resistor r=1T
B7_SN7p (B7_h7p B7_ck7 B7_fp 0) nmos_lvt l=30n w=2u multi=1 nf=1 sd=100n ad=1.5e-13 as=1.5e-13 pd=4.15u ps=4.15u nrd=0.144730 nrs=0.144730 sa=75.0n sb=75.0n sa1=75.0n sa2=75.0n sa3=75.0n sa4=75.0n sb1=75.0n sb2=75.0n sb3=75.0n spa=100n spa1=100n spa2=100n spa3=100n sap=91.9776n sapb=114.444n spba=115.715n spba1=117.043n dfm_flag=0 _ccoflag=1 _rcoflag=1 _rgflag=1 spmt=1.11111e+15 spomt=0 spomt1=1.11111e+60 spmb=1.11111e+15 spomb=0 spomb1=1.11111e+60
B7_SP7p (B7_h7p B7_kb7 B7_fp bankvdd) pmos_lvt l=30n w=2u multi=1 nf=1 sd=100n ad=1.5e-13 as=1.5e-13 pd=4.15u ps=4.15u nrd=0.082877 nrs=0.082877 sa=75.0n sb=75.0n sa1=75.0n sa2=75.0n sa3=75.0n sa4=75.0n sb1=75.0n sb2=75.0n sb3=75.0n spa=100n spa1=100n spa2=100n spa3=100n sap=91.9776n sapb=114.444n spba=115.715n spba1=117.043n dfm_flag=0 _ccoflag=1 _rcoflag=1 _rgflag=1 spmt=1.11111e+15 spomt=0 spomt1=1.11111e+60 spmb=1.11111e+15 spomb=0 spomb1=1.11111e+60
B7_CH7p (B7_h7p 0) capacitor c=2.5e-14
B7_RH7p (B7_h7p B7_fp) resistor r=1T
RB7_Lm (bankvdd B7_fm) resistor r=500
B7_Fm (B7_fm X_h7m B7_em 0) nmos_lvt l=30n w=2u multi=1 nf=1 sd=100n ad=1.5e-13 as=1.5e-13 pd=4.15u ps=4.15u nrd=0.144730 nrs=0.144730 sa=75.0n sb=75.0n sa1=75.0n sa2=75.0n sa3=75.0n sa4=75.0n sb1=75.0n sb2=75.0n sb3=75.0n spa=100n spa1=100n spa2=100n spa3=100n sap=91.9776n sapb=114.444n spba=115.715n spba1=117.043n dfm_flag=0 _ccoflag=1 _rcoflag=1 _rgflag=1 spmt=1.11111e+15 spomt=0 spomt1=1.11111e+60 spmb=1.11111e+15 spomb=0 spomb1=1.11111e+60
B7_Tm (B7_em nbias 0 0) nmos_lvt l=60n w=2u multi=1 nf=1 sd=100n ad=1.5e-13 as=1.5e-13 pd=4.15u ps=4.15u nrd=0.144730 nrs=0.144730 sa=75.0n sb=75.0n sa1=75.0n sa2=75.0n sa3=75.0n sa4=75.0n sb1=75.0n sb2=75.0n sb3=75.0n spa=100n spa1=100n spa2=100n spa3=100n sap=91.9776n sapb=120.93n spba=121.82n spba1=124.403n dfm_flag=0 _ccoflag=1 _rcoflag=1 _rgflag=1 spmt=1.11111e+15 spomt=0 spomt1=1.11111e+60 spmb=1.11111e+15 spomb=0 spomb1=1.11111e+60
B7_SN0m (B7_h0m B7_ck0 B7_fm 0) nmos_lvt l=30n w=2u multi=1 nf=1 sd=100n ad=1.5e-13 as=1.5e-13 pd=4.15u ps=4.15u nrd=0.144730 nrs=0.144730 sa=75.0n sb=75.0n sa1=75.0n sa2=75.0n sa3=75.0n sa4=75.0n sb1=75.0n sb2=75.0n sb3=75.0n spa=100n spa1=100n spa2=100n spa3=100n sap=91.9776n sapb=114.444n spba=115.715n spba1=117.043n dfm_flag=0 _ccoflag=1 _rcoflag=1 _rgflag=1 spmt=1.11111e+15 spomt=0 spomt1=1.11111e+60 spmb=1.11111e+15 spomb=0 spomb1=1.11111e+60
B7_SP0m (B7_h0m B7_kb0 B7_fm bankvdd) pmos_lvt l=30n w=2u multi=1 nf=1 sd=100n ad=1.5e-13 as=1.5e-13 pd=4.15u ps=4.15u nrd=0.082877 nrs=0.082877 sa=75.0n sb=75.0n sa1=75.0n sa2=75.0n sa3=75.0n sa4=75.0n sb1=75.0n sb2=75.0n sb3=75.0n spa=100n spa1=100n spa2=100n spa3=100n sap=91.9776n sapb=114.444n spba=115.715n spba1=117.043n dfm_flag=0 _ccoflag=1 _rcoflag=1 _rgflag=1 spmt=1.11111e+15 spomt=0 spomt1=1.11111e+60 spmb=1.11111e+15 spomb=0 spomb1=1.11111e+60
B7_CH0m (B7_h0m 0) capacitor c=2.5e-14
B7_RH0m (B7_h0m B7_fm) resistor r=1T
B7_SN1m (B7_h1m B7_ck1 B7_fm 0) nmos_lvt l=30n w=2u multi=1 nf=1 sd=100n ad=1.5e-13 as=1.5e-13 pd=4.15u ps=4.15u nrd=0.144730 nrs=0.144730 sa=75.0n sb=75.0n sa1=75.0n sa2=75.0n sa3=75.0n sa4=75.0n sb1=75.0n sb2=75.0n sb3=75.0n spa=100n spa1=100n spa2=100n spa3=100n sap=91.9776n sapb=114.444n spba=115.715n spba1=117.043n dfm_flag=0 _ccoflag=1 _rcoflag=1 _rgflag=1 spmt=1.11111e+15 spomt=0 spomt1=1.11111e+60 spmb=1.11111e+15 spomb=0 spomb1=1.11111e+60
B7_SP1m (B7_h1m B7_kb1 B7_fm bankvdd) pmos_lvt l=30n w=2u multi=1 nf=1 sd=100n ad=1.5e-13 as=1.5e-13 pd=4.15u ps=4.15u nrd=0.082877 nrs=0.082877 sa=75.0n sb=75.0n sa1=75.0n sa2=75.0n sa3=75.0n sa4=75.0n sb1=75.0n sb2=75.0n sb3=75.0n spa=100n spa1=100n spa2=100n spa3=100n sap=91.9776n sapb=114.444n spba=115.715n spba1=117.043n dfm_flag=0 _ccoflag=1 _rcoflag=1 _rgflag=1 spmt=1.11111e+15 spomt=0 spomt1=1.11111e+60 spmb=1.11111e+15 spomb=0 spomb1=1.11111e+60
B7_CH1m (B7_h1m 0) capacitor c=2.5e-14
B7_RH1m (B7_h1m B7_fm) resistor r=1T
B7_SN2m (B7_h2m B7_ck2 B7_fm 0) nmos_lvt l=30n w=2u multi=1 nf=1 sd=100n ad=1.5e-13 as=1.5e-13 pd=4.15u ps=4.15u nrd=0.144730 nrs=0.144730 sa=75.0n sb=75.0n sa1=75.0n sa2=75.0n sa3=75.0n sa4=75.0n sb1=75.0n sb2=75.0n sb3=75.0n spa=100n spa1=100n spa2=100n spa3=100n sap=91.9776n sapb=114.444n spba=115.715n spba1=117.043n dfm_flag=0 _ccoflag=1 _rcoflag=1 _rgflag=1 spmt=1.11111e+15 spomt=0 spomt1=1.11111e+60 spmb=1.11111e+15 spomb=0 spomb1=1.11111e+60
B7_SP2m (B7_h2m B7_kb2 B7_fm bankvdd) pmos_lvt l=30n w=2u multi=1 nf=1 sd=100n ad=1.5e-13 as=1.5e-13 pd=4.15u ps=4.15u nrd=0.082877 nrs=0.082877 sa=75.0n sb=75.0n sa1=75.0n sa2=75.0n sa3=75.0n sa4=75.0n sb1=75.0n sb2=75.0n sb3=75.0n spa=100n spa1=100n spa2=100n spa3=100n sap=91.9776n sapb=114.444n spba=115.715n spba1=117.043n dfm_flag=0 _ccoflag=1 _rcoflag=1 _rgflag=1 spmt=1.11111e+15 spomt=0 spomt1=1.11111e+60 spmb=1.11111e+15 spomb=0 spomb1=1.11111e+60
B7_CH2m (B7_h2m 0) capacitor c=2.5e-14
B7_RH2m (B7_h2m B7_fm) resistor r=1T
B7_SN3m (B7_h3m B7_ck3 B7_fm 0) nmos_lvt l=30n w=2u multi=1 nf=1 sd=100n ad=1.5e-13 as=1.5e-13 pd=4.15u ps=4.15u nrd=0.144730 nrs=0.144730 sa=75.0n sb=75.0n sa1=75.0n sa2=75.0n sa3=75.0n sa4=75.0n sb1=75.0n sb2=75.0n sb3=75.0n spa=100n spa1=100n spa2=100n spa3=100n sap=91.9776n sapb=114.444n spba=115.715n spba1=117.043n dfm_flag=0 _ccoflag=1 _rcoflag=1 _rgflag=1 spmt=1.11111e+15 spomt=0 spomt1=1.11111e+60 spmb=1.11111e+15 spomb=0 spomb1=1.11111e+60
B7_SP3m (B7_h3m B7_kb3 B7_fm bankvdd) pmos_lvt l=30n w=2u multi=1 nf=1 sd=100n ad=1.5e-13 as=1.5e-13 pd=4.15u ps=4.15u nrd=0.082877 nrs=0.082877 sa=75.0n sb=75.0n sa1=75.0n sa2=75.0n sa3=75.0n sa4=75.0n sb1=75.0n sb2=75.0n sb3=75.0n spa=100n spa1=100n spa2=100n spa3=100n sap=91.9776n sapb=114.444n spba=115.715n spba1=117.043n dfm_flag=0 _ccoflag=1 _rcoflag=1 _rgflag=1 spmt=1.11111e+15 spomt=0 spomt1=1.11111e+60 spmb=1.11111e+15 spomb=0 spomb1=1.11111e+60
B7_CH3m (B7_h3m 0) capacitor c=2.5e-14
B7_RH3m (B7_h3m B7_fm) resistor r=1T
B7_SN4m (B7_h4m B7_ck4 B7_fm 0) nmos_lvt l=30n w=2u multi=1 nf=1 sd=100n ad=1.5e-13 as=1.5e-13 pd=4.15u ps=4.15u nrd=0.144730 nrs=0.144730 sa=75.0n sb=75.0n sa1=75.0n sa2=75.0n sa3=75.0n sa4=75.0n sb1=75.0n sb2=75.0n sb3=75.0n spa=100n spa1=100n spa2=100n spa3=100n sap=91.9776n sapb=114.444n spba=115.715n spba1=117.043n dfm_flag=0 _ccoflag=1 _rcoflag=1 _rgflag=1 spmt=1.11111e+15 spomt=0 spomt1=1.11111e+60 spmb=1.11111e+15 spomb=0 spomb1=1.11111e+60
B7_SP4m (B7_h4m B7_kb4 B7_fm bankvdd) pmos_lvt l=30n w=2u multi=1 nf=1 sd=100n ad=1.5e-13 as=1.5e-13 pd=4.15u ps=4.15u nrd=0.082877 nrs=0.082877 sa=75.0n sb=75.0n sa1=75.0n sa2=75.0n sa3=75.0n sa4=75.0n sb1=75.0n sb2=75.0n sb3=75.0n spa=100n spa1=100n spa2=100n spa3=100n sap=91.9776n sapb=114.444n spba=115.715n spba1=117.043n dfm_flag=0 _ccoflag=1 _rcoflag=1 _rgflag=1 spmt=1.11111e+15 spomt=0 spomt1=1.11111e+60 spmb=1.11111e+15 spomb=0 spomb1=1.11111e+60
B7_CH4m (B7_h4m 0) capacitor c=2.5e-14
B7_RH4m (B7_h4m B7_fm) resistor r=1T
B7_SN5m (B7_h5m B7_ck5 B7_fm 0) nmos_lvt l=30n w=2u multi=1 nf=1 sd=100n ad=1.5e-13 as=1.5e-13 pd=4.15u ps=4.15u nrd=0.144730 nrs=0.144730 sa=75.0n sb=75.0n sa1=75.0n sa2=75.0n sa3=75.0n sa4=75.0n sb1=75.0n sb2=75.0n sb3=75.0n spa=100n spa1=100n spa2=100n spa3=100n sap=91.9776n sapb=114.444n spba=115.715n spba1=117.043n dfm_flag=0 _ccoflag=1 _rcoflag=1 _rgflag=1 spmt=1.11111e+15 spomt=0 spomt1=1.11111e+60 spmb=1.11111e+15 spomb=0 spomb1=1.11111e+60
B7_SP5m (B7_h5m B7_kb5 B7_fm bankvdd) pmos_lvt l=30n w=2u multi=1 nf=1 sd=100n ad=1.5e-13 as=1.5e-13 pd=4.15u ps=4.15u nrd=0.082877 nrs=0.082877 sa=75.0n sb=75.0n sa1=75.0n sa2=75.0n sa3=75.0n sa4=75.0n sb1=75.0n sb2=75.0n sb3=75.0n spa=100n spa1=100n spa2=100n spa3=100n sap=91.9776n sapb=114.444n spba=115.715n spba1=117.043n dfm_flag=0 _ccoflag=1 _rcoflag=1 _rgflag=1 spmt=1.11111e+15 spomt=0 spomt1=1.11111e+60 spmb=1.11111e+15 spomb=0 spomb1=1.11111e+60
B7_CH5m (B7_h5m 0) capacitor c=2.5e-14
B7_RH5m (B7_h5m B7_fm) resistor r=1T
B7_SN6m (B7_h6m B7_ck6 B7_fm 0) nmos_lvt l=30n w=2u multi=1 nf=1 sd=100n ad=1.5e-13 as=1.5e-13 pd=4.15u ps=4.15u nrd=0.144730 nrs=0.144730 sa=75.0n sb=75.0n sa1=75.0n sa2=75.0n sa3=75.0n sa4=75.0n sb1=75.0n sb2=75.0n sb3=75.0n spa=100n spa1=100n spa2=100n spa3=100n sap=91.9776n sapb=114.444n spba=115.715n spba1=117.043n dfm_flag=0 _ccoflag=1 _rcoflag=1 _rgflag=1 spmt=1.11111e+15 spomt=0 spomt1=1.11111e+60 spmb=1.11111e+15 spomb=0 spomb1=1.11111e+60
B7_SP6m (B7_h6m B7_kb6 B7_fm bankvdd) pmos_lvt l=30n w=2u multi=1 nf=1 sd=100n ad=1.5e-13 as=1.5e-13 pd=4.15u ps=4.15u nrd=0.082877 nrs=0.082877 sa=75.0n sb=75.0n sa1=75.0n sa2=75.0n sa3=75.0n sa4=75.0n sb1=75.0n sb2=75.0n sb3=75.0n spa=100n spa1=100n spa2=100n spa3=100n sap=91.9776n sapb=114.444n spba=115.715n spba1=117.043n dfm_flag=0 _ccoflag=1 _rcoflag=1 _rgflag=1 spmt=1.11111e+15 spomt=0 spomt1=1.11111e+60 spmb=1.11111e+15 spomb=0 spomb1=1.11111e+60
B7_CH6m (B7_h6m 0) capacitor c=2.5e-14
B7_RH6m (B7_h6m B7_fm) resistor r=1T
B7_SN7m (B7_h7m B7_ck7 B7_fm 0) nmos_lvt l=30n w=2u multi=1 nf=1 sd=100n ad=1.5e-13 as=1.5e-13 pd=4.15u ps=4.15u nrd=0.144730 nrs=0.144730 sa=75.0n sb=75.0n sa1=75.0n sa2=75.0n sa3=75.0n sa4=75.0n sb1=75.0n sb2=75.0n sb3=75.0n spa=100n spa1=100n spa2=100n spa3=100n sap=91.9776n sapb=114.444n spba=115.715n spba1=117.043n dfm_flag=0 _ccoflag=1 _rcoflag=1 _rgflag=1 spmt=1.11111e+15 spomt=0 spomt1=1.11111e+60 spmb=1.11111e+15 spomb=0 spomb1=1.11111e+60
B7_SP7m (B7_h7m B7_kb7 B7_fm bankvdd) pmos_lvt l=30n w=2u multi=1 nf=1 sd=100n ad=1.5e-13 as=1.5e-13 pd=4.15u ps=4.15u nrd=0.082877 nrs=0.082877 sa=75.0n sb=75.0n sa1=75.0n sa2=75.0n sa3=75.0n sa4=75.0n sb1=75.0n sb2=75.0n sb3=75.0n spa=100n spa1=100n spa2=100n spa3=100n sap=91.9776n sapb=114.444n spba=115.715n spba1=117.043n dfm_flag=0 _ccoflag=1 _rcoflag=1 _rgflag=1 spmt=1.11111e+15 spomt=0 spomt1=1.11111e+60 spmb=1.11111e+15 spomb=0 spomb1=1.11111e+60
B7_CH7m (B7_h7m 0) capacitor c=2.5e-14
B7_RH7m (B7_h7m B7_fm) resistor r=1T
B7_RDEG (B7_ep B7_em) resistor r=250
B7_COMP0 (B7_h0p B7_h0m compvdd logicvdd) COMPLOAD
B7_COMP1 (B7_h1p B7_h1m compvdd logicvdd) COMPLOAD
B7_COMP2 (B7_h2p B7_h2m compvdd logicvdd) COMPLOAD
B7_COMP3 (B7_h3p B7_h3m compvdd logicvdd) COMPLOAD
B7_COMP4 (B7_h4p B7_h4m compvdd logicvdd) COMPLOAD
B7_COMP5 (B7_h5p B7_h5m compvdd logicvdd) COMPLOAD
B7_COMP6 (B7_h6p B7_h6m compvdd logicvdd) COMPLOAD
B7_COMP7 (B7_h7p B7_h7m compvdd logicvdd) COMPLOAD
saveOptions options save=selected currents=selected
save X_o_p X_o_m X_ip X_im X_ck0 X_kb0 XVs:p X_h0p X_h0m X_h1p X_h1m X_h2p X_h2m X_h3p X_h3m X_h4p X_h4m X_h5p X_h5m X_h6p X_h6m X_h7p X_h7m VBANK:p VNBIAS:p VPBIAS:p VCOMP:p VLOGIC:p B0_ck0 B0_kb0 B0_ck7 B0_kb7 B0_fp B0_ep B0_h0p B0_h1p B0_h2p B0_h3p B0_h4p B0_h5p B0_h6p B0_h7p B0_fm B0_em B0_h0m B0_h1m B0_h2m B0_h3m B0_h4m B0_h5m B0_h6m B0_h7m B1_h0p B1_h1p B1_h2p B1_h3p B1_h4p B1_h5p B1_h6p B1_h7p B1_h0m B1_h1m B1_h2m B1_h3m B1_h4m B1_h5m B1_h6m B1_h7m B2_h0p B2_h1p B2_h2p B2_h3p B2_h4p B2_h5p B2_h6p B2_h7p B2_h0m B2_h1m B2_h2m B2_h3m B2_h4m B2_h5m B2_h6m B2_h7m B3_h0p B3_h1p B3_h2p B3_h3p B3_h4p B3_h5p B3_h6p B3_h7p B3_h0m B3_h1m B3_h2m B3_h3m B3_h4m B3_h5m B3_h6m B3_h7m B4_h0p B4_h1p B4_h2p B4_h3p B4_h4p B4_h5p B4_h6p B4_h7p B4_h0m B4_h1m B4_h2m B4_h3m B4_h4m B4_h5m B4_h6m B4_h7m B5_h0p B5_h1p B5_h2p B5_h3p B5_h4p B5_h5p B5_h6p B5_h7p B5_h0m B5_h1m B5_h2m B5_h3m B5_h4m B5_h5m B5_h6m B5_h7m B6_h0p B6_h1p B6_h2p B6_h3p B6_h4p B6_h5p B6_h6p B6_h7p B6_h0m B6_h1m B6_h2m B6_h3m B6_h4m B6_h5m B6_h6m B6_h7m B7_ck7 B7_kb7 B7_fp B7_ep B7_h0p B7_h1p B7_h2p B7_h3p B7_h4p B7_h5p B7_h6p B7_h7p B7_fm B7_em B7_h0m B7_h1m B7_h2m B7_h3m B7_h4m B7_h5m B7_h6m B7_h7m
dcOp dc
tranResponse tran stop=2.198571428571428e-08 maxstep=200f errpreset=conservative strobeperiod=1.116071428571429e-12 strobeoutput=strobeonly noisefmax=150G noisefmin=500M noiseseed=251
